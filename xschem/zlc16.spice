** sch_path: /home/me/Desktop/Project/sky130_adder_4bit/xschem/zlc16.sch
.subckt zlc16 Y[4] Y[3] Y[2] Y[1] Y[0] A[15] A[14] A[13] A[12] A[11] A[10] A[9] A[8] A[7] A[6] A[5] A[4] A[3] A[2] A[1] A[0] VDD
+ GND
*.PININFO VDD:I GND:I A[15:0]:I Y[4:0]:O
x3 net1 net13 GND GND VDD VDD net12 sky130_fd_sc_hd__or2_1
x4 net1 GND GND VDD VDD net8 sky130_fd_sc_hd__inv_1
x5 net6 net7 net8 GND GND VDD VDD net11 sky130_fd_sc_hd__mux2_1
x6 net4 net5 net8 GND GND VDD VDD net10 sky130_fd_sc_hd__mux2_1
x7 net2 net3 net8 GND GND VDD VDD net9 sky130_fd_sc_hd__mux2_1
x8 net8 net12 GND GND VDD VDD Y[3] sky130_fd_sc_hd__and2_1
x9 net9 net12 GND GND VDD VDD Y[2] sky130_fd_sc_hd__and2_1
x10 net10 net12 GND GND VDD VDD Y[1] sky130_fd_sc_hd__and2_1
x11 net11 net12 GND GND VDD VDD Y[0] sky130_fd_sc_hd__and2_1
x12 net12 GND GND VDD VDD Y[4] sky130_fd_sc_hd__inv_1
x1 A[15] A[14] net1 A[13] A[12] net2 A[11] A[10] net4 A[9] A[8] net6 VDD GND zlc8
x2 A[7] A[6] net13 A[5] A[4] net3 A[3] A[2] net5 A[1] A[0] net7 VDD GND zlc8
.ends

* expanding   symbol:  zlc8.sym # of pins=14
** sym_path: /home/me/Desktop/Project/sky130_adder_4bit/xschem/zlc8.sym
** sch_path: /home/me/Desktop/Project/sky130_adder_4bit/xschem/zlc8.sch
.subckt zlc8 A7 A6 V A5 A4 P2 A3 A2 P1 A1 A0 P0 VDD GND
*.PININFO A7:I A6:I A5:I A4:I A3:I A2:I A1:I A0:I V:O P2:O P1:O P0:O VDD:I GND:I
x3 net1 net3 GND GND VDD VDD V sky130_fd_sc_hd__or2_1
x4 net1 GND GND VDD VDD P2 sky130_fd_sc_hd__inv_1
x5 net2 net4 P2 GND GND VDD VDD P1 sky130_fd_sc_hd__mux2_1
x6 net5 net6 P2 GND GND VDD VDD P0 sky130_fd_sc_hd__mux2_1
x1 A7 net1 A6 net2 A5 A4 net5 VDD GND zlc4
x2 A3 net3 A2 net4 A1 A0 net6 VDD GND zlc4
.ends

* expanding   symbol:  zlc4.sym # of pins=9
** sym_path: /home/me/Desktop/Project/sky130_adder_4bit/xschem/zlc4.sym
** sch_path: /home/me/Desktop/Project/sky130_adder_4bit/xschem/zlc4.sch
.subckt zlc4 A3 V A2 P1 A1 A0 P0 VDD GND
*.PININFO A3:I A2:I A1:I A0:I V:O P1:O P0:O VDD:I GND:I
x3 net1 net2 GND GND VDD VDD V sky130_fd_sc_hd__or2_1
x4 net1 GND GND VDD VDD P1 sky130_fd_sc_hd__inv_1
x5 net3 net4 P1 GND GND VDD VDD P0 sky130_fd_sc_hd__mux2_1
x1 A3 net1 A2 net3 VDD GND zlc2
x2 A1 net2 A0 net4 VDD GND zlc2
.ends

* expanding   symbol:  zlc2.sym # of pins=6
** sym_path: /home/me/Desktop/Project/sky130_adder_4bit/xschem/zlc2.sym
** sch_path: /home/me/Desktop/Project/sky130_adder_4bit/xschem/zlc2.sch
.subckt zlc2 HI V LO P VDD GND
*.PININFO HI:I LO:I V:O P:O VDD:I GND:I
x1 HI LO GND GND VDD VDD V sky130_fd_sc_hd__or2_1
x2 HI GND GND VDD VDD P sky130_fd_sc_hd__inv_1
.ends
