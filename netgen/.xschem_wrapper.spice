.include /usr/local/share/pdk/sky130A/libs.ref/sky130_fd_sc_hd/spice/sky130_fd_sc_hd.spice
.include /home/me/Desktop/Project/sky130_adder_4bit/xschem/zlc16.spice
