* =============================================================
* Testbench: 16-bit Zero Leading Counter: multi-case functional test
* Process  : SkyWater SKY130 (sky130_fd_sc_hd)
* Stimulus : Apply multiple input patterns to A[15:0]
* Check    : Verify Y[4:0] leading-zero count output
* =============================================================

* ---- Include PDK libs ----------------------------------------
.lib $PDK_ROOT/$PDK/libs.tech/combined/sky130.lib.spice tt

* uncomment this line if DUT is a xschem netlist
*.include $PDK_ROOT/$PDK/libs.ref/sky130_fd_sc_hd/spice/sky130_fd_sc_hd.spice

* ---- Include DUT ---------------------------------------------
.include $PWD/../magic/zlc16.rcx.spice

* ---- Global supply -------------------------------------------
.global VDD VSS
Vvdd VDD 0 DC 1.8
Vvss VSS 0 DC 0

* ---- Stimulus sources: multi-case functional test -------------
* Case 1: 0ns    -> 2ns    : A = 16'h0004 => Y = 13 = 01101
* Case 2: 2.05ns -> 4ns    : A = 16'h000C => Y = 12 = 01100
* Case 3: 4.05ns -> 6ns    : A = 16'h0010 => Y = 11 = 01011
* Case 4: 6.05ns -> 8ns    : A = 16'h0100 => Y = 7  = 00111
* Case 5: 8.05ns -> 10ns   : A = 16'h4000 => Y = 1  = 00001
* Case 6: 10.05ns -> 12ns  : A = 16'h8000 => Y = 0  = 00000
* Case 7: 12.05ns -> 14ns  : A = 16'h0001 => Y = 15 = 01111
* Case 8: 14.05ns -> 20ns  : A = 16'h0000 => Y = 16 = 10000

Va15 A15 0 PWL(
+ 0ns     0
+ 10ns    0
+ 10.05ns 1.8
+ 12ns    1.8
+ 12.05ns 0
+ 20ns    0
+ )

Va14 A14 0 PWL(
+ 0ns     0
+ 8ns     0
+ 8.05ns  1.8
+ 10ns    1.8
+ 10.05ns 0
+ 20ns    0
+ )

Va13 A13 0 DC 0
Va12 A12 0 DC 0
Va11 A11 0 DC 0
Va10 A10 0 DC 0
Va9  A9  0 DC 0

Va8 A8 0 PWL(
+ 0ns    0
+ 6ns    0
+ 6.05ns 1.8
+ 8ns    1.8
+ 8.05ns 0
+ 20ns   0
+ )

Va7 A7 0 DC 0
Va6 A6 0 DC 0
Va5 A5 0 DC 0

Va4 A4 0 PWL(
+ 0ns    0
+ 4ns    0
+ 4.05ns 1.8
+ 6ns    1.8
+ 6.05ns 0
+ 20ns   0
+ )

Va3 A3 0 PWL(
+ 0ns    0
+ 2ns    0
+ 2.05ns 1.8
+ 4ns    1.8
+ 4.05ns 0
+ 20ns   0
+ )

Va2 A2 0 PWL(
+ 0ns    1.8
+ 4ns    1.8
+ 4.05ns 0
+ 20ns   0
+ )

Va1 A1 0 DC 0

Va0 A0 0 PWL(
+ 0ns     0
+ 12ns    0
+ 12.05ns 1.8
+ 14ns    1.8
+ 14.05ns 0
+ 20ns    0
+ )

* ---- DUT: 16-bit Zero Leading Counter ------------------------
* Extracted subckt order:
* .subckt zlc16 A[0] A[1] ... A[15] Y[0] Y[1] Y[2] Y[3] Y[4] VDD GND
*
* The extracted GND pin is connected to VSS in this testbench.
Xzlc16 A0 A1 A2 A3 A4 A5 A6 A7 A8 A9 A10 A11 A12 A13 A14 A15 Y0 Y1 Y2 Y3 Y4 VDD VSS zlc16

* ---- Load capacitance ----------------------------------------
Cload_y0 Y0 0 0.01pF
Cload_y1 Y1 0 0.01pF
Cload_y2 Y2 0 0.01pF
Cload_y3 Y3 0 0.01pF
Cload_y4 Y4 0 0.01pF

* ---- Batch mode ----------------------------------------------
* run ngspice with -b flag, -r flag is used to write raw waveform file
.tran 1ps 20ns
.save v(A15) v(A14) v(A8) v(A4) v(A3) v(A2) v(A0) v(Y0) v(Y1) v(Y2) v(Y3) v(Y4)

*----- Interactive mode----------------------------------------
* run ngspice without -b or -r flag to enter interactive mode
* command run one by one sequentially, add quit at the end to exit ngspice
* useful for scripting with if/else, for loop logic
*.control
*tran 1ps 20ns
*write zlc16.raw all
*meas tran tpd_a3_y0_fall trig v(A3) val=0.9 rise=1 targ v(Y0) val=0.9 fall=1
*meas tran tpd_a3_y0_rise trig v(A3) val=0.9 fall=1 targ v(Y0) val=0.9 rise=1
*print tpd_a3_y0_fall tpd_a3_y0_rise
*.endc

.end
