* NGSPICE file created from zlc8.ext - technology: sky130A

.subckt zlc8 A0 A1 A2 A3 A4 A5 A7 A6 P2 V P0 P1 VDD GND
X0 P1.t0 a_4903_n1962# VDD.t16 VDD.t15 sky130_fd_pr__pfet_01v8_hvt ad=0.26 pd=2.52 as=0.15835 ps=1.395 w=1 l=0.15
X1 a_5279_n2314# x5.A1 VDD.t52 VDD.t51 sky130_fd_pr__pfet_01v8_hvt ad=0.07665 pd=0.785 as=0.15835 ps=1.395 w=0.42 l=0.15
X2 GND.t13 x3.B a_5789_n1769# GND.t12 sky130_fd_pr__nfet_01v8 ad=0.1092 pd=1.36 as=0.0567 ps=0.69 w=0.42 l=0.15
X3 a_3359_n2391# A0.t0 GND.t85 GND.t84 sky130_fd_pr__nfet_01v8 ad=0.0567 pd=0.69 as=0.1092 ps=1.36 w=0.42 l=0.15
X4 GND.t71 A5.t1 a_3360_n1111# GND.t70 sky130_fd_pr__nfet_01v8 ad=0.10025 pd=0.985 as=0.0567 ps=0.69 w=0.42 l=0.15
X5 VDD.t67 A5.t3 a_3442_n1111# VDD.t66 sky130_fd_pr__pfet_01v8_hvt ad=0.14575 pd=1.335 as=0.0441 ps=0.63 w=0.42 l=0.15
X6 a_5957_n2391# x2.x3.B GND.t21 GND.t20 sky130_fd_pr__nfet_01v8 ad=0.0567 pd=0.69 as=0.1092 ps=1.36 w=0.42 l=0.15
X7 x2.x3.B a_3359_n2391# VDD.t58 VDD.t57 sky130_fd_pr__pfet_01v8_hvt ad=0.34 pd=2.68 as=0.14575 ps=1.335 w=1 l=0.15
X8 a_4264_n1111# A6.t0 GND.t75 GND.t74 sky130_fd_pr__nfet_01v8 ad=0.0567 pd=0.69 as=0.1092 ps=1.36 w=0.42 l=0.15
X9 a_5500_n2641# x2.x5.A0 a_5137_n2489# GND.t38 sky130_fd_pr__nfet_01v8 ad=0.0693 pd=0.75 as=0.09975 ps=0.895 w=0.42 l=0.15
X10 GND.t29 a_5137_n2489# x6.A1 GND.t28 sky130_fd_pr__nfet_01v8 ad=0.11285 pd=1.045 as=0.169 ps=1.82 w=0.65 l=0.15
X11 a_5958_n1111# x1.x3.B GND.t59 GND.t58 sky130_fd_pr__nfet_01v8 ad=0.0567 pd=0.69 as=0.1092 ps=1.36 w=0.42 l=0.15
X12 a_5280_n1361# x5.A0 GND.t42 GND.t41 sky130_fd_pr__nfet_01v8 ad=0.0693 pd=0.75 as=0.11285 ps=1.045 w=0.42 l=0.15
X13 VDD.t86 A3.t3 a_4345_n2391# VDD.t85 sky130_fd_pr__pfet_01v8_hvt ad=0.14575 pd=1.335 as=0.0441 ps=0.63 w=0.42 l=0.15
X14 VDD.t23 x2.x4.A a_6039_n2391# VDD.t22 sky130_fd_pr__pfet_01v8_hvt ad=0.14575 pd=1.335 as=0.0441 ps=0.63 w=0.42 l=0.15
X15 a_5501_n1361# x1.x5.A0 a_5138_n1209# GND.t46 sky130_fd_pr__nfet_01v8 ad=0.0693 pd=0.75 as=0.09975 ps=0.895 w=0.42 l=0.15
X16 GND.t2 a_5138_n1209# x6.A0 GND.t1 sky130_fd_pr__nfet_01v8 ad=0.11285 pd=1.045 as=0.169 ps=1.82 w=0.65 l=0.15
X17 VDD.t2 a_5138_n1209# x6.A0 VDD.t1 sky130_fd_pr__pfet_01v8_hvt ad=0.15835 pd=1.395 as=0.26 ps=2.52 w=1 l=0.15
X18 a_5596_n2314# x2.x5.A1 a_5137_n2489# VDD.t0 sky130_fd_pr__pfet_01v8_hvt ad=0.0441 pd=0.63 as=0.1932 ps=1.34 w=0.42 l=0.15
X19 a_3360_n1111# A4.t0 GND.t69 GND.t68 sky130_fd_pr__nfet_01v8 ad=0.0567 pd=0.69 as=0.1092 ps=1.36 w=0.42 l=0.15
X20 x3.B a_5957_n2391# VDD.t25 VDD.t24 sky130_fd_pr__pfet_01v8_hvt ad=0.34 pd=2.68 as=0.14575 ps=1.335 w=1 l=0.15
X21 VDD.t64 a_5566_n2667# a_5596_n2314# VDD.t63 sky130_fd_pr__pfet_01v8_hvt ad=0.0693 pd=0.75 as=0.0441 ps=0.63 w=0.42 l=0.15
X22 a_4346_n1111# A6.t1 a_4264_n1111# VDD.t70 sky130_fd_pr__pfet_01v8_hvt ad=0.0441 pd=0.63 as=0.1092 ps=1.36 w=0.42 l=0.15
X23 a_5597_n1034# x1.x5.A1 a_5138_n1209# VDD.t55 sky130_fd_pr__pfet_01v8_hvt ad=0.0441 pd=0.63 as=0.1932 ps=1.34 w=0.42 l=0.15
X24 VDD.t81 A1.t3 a_3441_n2391# VDD.t80 sky130_fd_pr__pfet_01v8_hvt ad=0.14575 pd=1.335 as=0.0441 ps=0.63 w=0.42 l=0.15
X25 a_6040_n1111# x1.x3.B a_5958_n1111# VDD.t56 sky130_fd_pr__pfet_01v8_hvt ad=0.0441 pd=0.63 as=0.1092 ps=1.36 w=0.42 l=0.15
X26 GND.t15 a_5789_n1769# V.t1 GND.t14 sky130_fd_pr__nfet_01v8 ad=0.10025 pd=0.985 as=0.169 ps=1.82 w=0.65 l=0.15
X27 VDD.t47 a_5567_n1387# a_5597_n1034# VDD.t46 sky130_fd_pr__pfet_01v8_hvt ad=0.0693 pd=0.75 as=0.0441 ps=0.63 w=0.42 l=0.15
X28 a_5279_n2641# x5.A1 GND.t52 GND.t51 sky130_fd_pr__nfet_01v8 ad=0.0693 pd=0.75 as=0.11285 ps=1.045 w=0.42 l=0.15
X29 a_5566_n2667# x5.A1 VDD.t50 VDD.t49 sky130_fd_pr__pfet_01v8_hvt ad=0.1176 pd=1.4 as=0.0693 ps=0.75 w=0.42 l=0.15
X30 x2.x5.A0 A3.t0 GND.t95 GND.t94 sky130_fd_pr__nfet_01v8 ad=0.169 pd=1.82 as=0.169 ps=1.82 w=0.65 l=0.15
X31 VDD.t27 a_5137_n2489# x6.A1 VDD.t26 sky130_fd_pr__pfet_01v8_hvt ad=0.15835 pd=1.395 as=0.26 ps=2.52 w=1 l=0.15
X32 a_3442_n1111# A4.t1 a_3360_n1111# VDD.t65 sky130_fd_pr__pfet_01v8_hvt ad=0.0441 pd=0.63 as=0.1092 ps=1.36 w=0.42 l=0.15
X33 a_5789_n1769# x3.B a_5952_n1885# VDD.t12 sky130_fd_pr__pfet_01v8_hvt ad=0.1092 pd=1.36 as=0.0441 ps=0.63 w=0.42 l=0.15
X34 a_5567_n1387# x5.A0 VDD.t40 VDD.t39 sky130_fd_pr__pfet_01v8_hvt ad=0.1176 pd=1.4 as=0.0693 ps=0.75 w=0.42 l=0.15
X35 VDD.t74 P2.t5 a_3821_n1962# VDD.t73 sky130_fd_pr__pfet_01v8_hvt ad=0.0693 pd=0.75 as=0.1176 ps=1.4 w=0.42 l=0.15
X36 GND.t79 P2.t9 a_3821_n1962# GND.t78 sky130_fd_pr__nfet_01v8 ad=0.1449 pd=1.11 as=0.1092 ps=1.36 w=0.42 l=0.15
X37 VDD.t14 a_5789_n1769# V.t0 VDD.t13 sky130_fd_pr__pfet_01v8_hvt ad=0.14575 pd=1.335 as=0.34 ps=2.68 w=1 l=0.15
X38 x1.x5.A0 A7.t0 GND.t65 GND.t64 sky130_fd_pr__nfet_01v8 ad=0.169 pd=1.82 as=0.169 ps=1.82 w=0.65 l=0.15
X39 x1.x5.A0 A7.t2 VDD.t60 VDD.t59 sky130_fd_pr__pfet_01v8_hvt ad=0.26 pd=2.52 as=0.26 ps=2.52 w=1 l=0.15
X40 a_4075_n1962# x6.A1 a_4003_n1962# VDD.t3 sky130_fd_pr__pfet_01v8_hvt ad=0.1932 pd=1.34 as=0.0441 ps=0.63 w=0.42 l=0.15
X41 a_5137_n2489# x2.x5.A1 a_5279_n2641# GND.t0 sky130_fd_pr__nfet_01v8 ad=0.09975 pd=0.895 as=0.0693 ps=0.75 w=0.42 l=0.15
X42 a_4075_n1635# a_3821_n1962# GND.t5 GND.t4 sky130_fd_pr__nfet_01v8 ad=0.0693 pd=0.75 as=0.1449 ps=1.11 w=0.42 l=0.15
X43 x5.A0 x1.x4.A GND.t33 GND.t32 sky130_fd_pr__nfet_01v8 ad=0.169 pd=1.82 as=0.169 ps=1.82 w=0.65 l=0.15
X44 a_4345_n2391# A2.t1 a_4263_n2391# VDD.t84 sky130_fd_pr__pfet_01v8_hvt ad=0.0441 pd=0.63 as=0.1092 ps=1.36 w=0.42 l=0.15
X45 x5.A0 x1.x4.A VDD.t31 VDD.t30 sky130_fd_pr__pfet_01v8_hvt ad=0.26 pd=2.52 as=0.26 ps=2.52 w=1 l=0.15
X46 GND.t67 a_5566_n2667# a_5500_n2641# GND.t66 sky130_fd_pr__nfet_01v8 ad=0.1449 pd=1.11 as=0.0693 ps=0.75 w=0.42 l=0.15
X47 a_4296_n1635# x6.A1 a_4075_n1962# GND.t3 sky130_fd_pr__nfet_01v8 ad=0.0693 pd=0.75 as=0.09975 ps=0.895 w=0.42 l=0.15
X48 a_5138_n1209# x1.x5.A1 a_5280_n1361# GND.t57 sky130_fd_pr__nfet_01v8 ad=0.09975 pd=0.895 as=0.0693 ps=0.75 w=0.42 l=0.15
X49 x2.x5.A1 A1.t0 GND.t87 GND.t86 sky130_fd_pr__nfet_01v8 ad=0.169 pd=1.82 as=0.169 ps=1.82 w=0.65 l=0.15
X50 a_5124_n1635# x5.A1 a_4903_n1962# GND.t50 sky130_fd_pr__nfet_01v8 ad=0.0693 pd=0.75 as=0.09975 ps=0.895 w=0.42 l=0.15
X51 a_4003_n1962# a_3821_n1962# VDD.t5 VDD.t4 sky130_fd_pr__pfet_01v8_hvt ad=0.0441 pd=0.63 as=0.0693 ps=0.75 w=0.42 l=0.15
X52 GND.t49 a_5567_n1387# a_5501_n1361# GND.t48 sky130_fd_pr__nfet_01v8 ad=0.1449 pd=1.11 as=0.0693 ps=0.75 w=0.42 l=0.15
X53 a_4075_n1962# x6.A0 a_4075_n1635# GND.t47 sky130_fd_pr__nfet_01v8 ad=0.09975 pd=0.895 as=0.0693 ps=0.75 w=0.42 l=0.15
X54 x1.x5.A1 A5.t0 GND.t73 GND.t72 sky130_fd_pr__nfet_01v8 ad=0.169 pd=1.82 as=0.169 ps=1.82 w=0.65 l=0.15
X55 x1.x5.A1 A5.t2 VDD.t69 VDD.t68 sky130_fd_pr__pfet_01v8_hvt ad=0.26 pd=2.52 as=0.26 ps=2.52 w=1 l=0.15
X56 a_3441_n2391# A0.t1 a_3359_n2391# VDD.t79 sky130_fd_pr__pfet_01v8_hvt ad=0.0441 pd=0.63 as=0.1092 ps=1.36 w=0.42 l=0.15
X57 a_4903_n1962# x5.A1 a_4831_n1962# VDD.t48 sky130_fd_pr__pfet_01v8_hvt ad=0.1932 pd=1.34 as=0.0441 ps=0.63 w=0.42 l=0.15
X58 VDD.t76 P2.t4 a_4289_n1962# VDD.t75 sky130_fd_pr__pfet_01v8_hvt ad=0.15835 pd=1.395 as=0.07665 ps=0.785 w=0.42 l=0.15
X59 GND.t77 P2.t8 a_4296_n1635# GND.t76 sky130_fd_pr__nfet_01v8 ad=0.11285 pd=1.045 as=0.0693 ps=0.75 w=0.42 l=0.15
X60 a_4903_n1635# a_4649_n1962# GND.t56 GND.t55 sky130_fd_pr__nfet_01v8 ad=0.0693 pd=0.75 as=0.1449 ps=1.11 w=0.42 l=0.15
X61 VDD.t72 P2.t2 a_5117_n1962# VDD.t71 sky130_fd_pr__pfet_01v8_hvt ad=0.15835 pd=1.395 as=0.07665 ps=0.785 w=0.42 l=0.15
X62 GND.t81 P2.t6 a_5124_n1635# GND.t80 sky130_fd_pr__nfet_01v8 ad=0.11285 pd=1.045 as=0.0693 ps=0.75 w=0.42 l=0.15
X63 GND.t9 x4.A P2.t1 GND.t8 sky130_fd_pr__nfet_01v8 ad=0.169 pd=1.82 as=0.169 ps=1.82 w=0.65 l=0.15
X64 a_5566_n2667# x5.A1 GND.t54 GND.t53 sky130_fd_pr__nfet_01v8 ad=0.1092 pd=1.36 as=0.1449 ps=1.11 w=0.42 l=0.15
X65 x2.x5.A0 A3.t2 VDD.t88 VDD.t87 sky130_fd_pr__pfet_01v8_hvt ad=0.26 pd=2.52 as=0.26 ps=2.52 w=1 l=0.15
X66 x5.A1 x2.x4.A GND.t25 GND.t24 sky130_fd_pr__nfet_01v8 ad=0.169 pd=1.82 as=0.169 ps=1.82 w=0.65 l=0.15
X67 P0.t1 a_4075_n1962# GND.t11 GND.t10 sky130_fd_pr__nfet_01v8 ad=0.169 pd=1.82 as=0.11285 ps=1.045 w=0.65 l=0.15
X68 a_5567_n1387# x5.A0 GND.t44 GND.t43 sky130_fd_pr__nfet_01v8 ad=0.1092 pd=1.36 as=0.1449 ps=1.11 w=0.42 l=0.15
X69 a_5952_n1885# x4.A VDD.t7 VDD.t6 sky130_fd_pr__pfet_01v8_hvt ad=0.0441 pd=0.63 as=0.14575 ps=1.335 w=0.42 l=0.15
X70 x2.x4.A a_4263_n2391# GND.t19 GND.t18 sky130_fd_pr__nfet_01v8 ad=0.169 pd=1.82 as=0.10025 ps=0.985 w=0.65 l=0.15
X71 a_6039_n2391# x2.x3.B a_5957_n2391# VDD.t19 sky130_fd_pr__pfet_01v8_hvt ad=0.0441 pd=0.63 as=0.1092 ps=1.36 w=0.42 l=0.15
X72 VDD.t9 x4.A P2.t0 VDD.t8 sky130_fd_pr__pfet_01v8_hvt ad=0.26 pd=2.52 as=0.26 ps=2.52 w=1 l=0.15
X73 x1.x4.A a_4264_n1111# GND.t40 GND.t39 sky130_fd_pr__nfet_01v8 ad=0.169 pd=1.82 as=0.10025 ps=0.985 w=0.65 l=0.15
X74 x2.x5.A1 A1.t2 VDD.t83 VDD.t82 sky130_fd_pr__pfet_01v8_hvt ad=0.26 pd=2.52 as=0.26 ps=2.52 w=1 l=0.15
X75 x1.x4.A a_4264_n1111# VDD.t38 VDD.t37 sky130_fd_pr__pfet_01v8_hvt ad=0.34 pd=2.68 as=0.14575 ps=1.335 w=1 l=0.15
X76 VDD.t78 P2.t3 a_4649_n1962# VDD.t77 sky130_fd_pr__pfet_01v8_hvt ad=0.0693 pd=0.75 as=0.1176 ps=1.4 w=0.42 l=0.15
X77 GND.t83 P2.t7 a_4649_n1962# GND.t82 sky130_fd_pr__nfet_01v8 ad=0.1449 pd=1.11 as=0.1092 ps=1.36 w=0.42 l=0.15
X78 P0.t0 a_4075_n1962# VDD.t11 VDD.t10 sky130_fd_pr__pfet_01v8_hvt ad=0.26 pd=2.52 as=0.15835 ps=1.395 w=1 l=0.15
X79 a_4289_n1962# x6.A0 a_4075_n1962# VDD.t45 sky130_fd_pr__pfet_01v8_hvt ad=0.07665 pd=0.785 as=0.1932 ps=1.34 w=0.42 l=0.15
X80 a_5137_n2489# x2.x5.A0 a_5279_n2314# VDD.t36 sky130_fd_pr__pfet_01v8_hvt ad=0.1932 pd=1.34 as=0.07665 ps=0.785 w=0.42 l=0.15
X81 x2.x3.B a_3359_n2391# GND.t61 GND.t60 sky130_fd_pr__nfet_01v8 ad=0.169 pd=1.82 as=0.10025 ps=0.985 w=0.65 l=0.15
X82 a_5117_n1962# x5.A0 a_4903_n1962# VDD.t43 sky130_fd_pr__pfet_01v8_hvt ad=0.07665 pd=0.785 as=0.1932 ps=1.34 w=0.42 l=0.15
X83 a_5280_n1034# x5.A0 VDD.t42 VDD.t41 sky130_fd_pr__pfet_01v8_hvt ad=0.07665 pd=0.785 as=0.15835 ps=1.395 w=0.42 l=0.15
X84 a_5138_n1209# x1.x5.A0 a_5280_n1034# VDD.t44 sky130_fd_pr__pfet_01v8_hvt ad=0.1932 pd=1.34 as=0.07665 ps=0.785 w=0.42 l=0.15
X85 a_4831_n1962# a_4649_n1962# VDD.t54 VDD.t53 sky130_fd_pr__pfet_01v8_hvt ad=0.0441 pd=0.63 as=0.0693 ps=0.75 w=0.42 l=0.15
X86 x1.x3.B a_3360_n1111# GND.t37 GND.t36 sky130_fd_pr__nfet_01v8 ad=0.169 pd=1.82 as=0.10025 ps=0.985 w=0.65 l=0.15
X87 x1.x3.B a_3360_n1111# VDD.t35 VDD.t34 sky130_fd_pr__pfet_01v8_hvt ad=0.34 pd=2.68 as=0.14575 ps=1.335 w=1 l=0.15
X88 GND.t93 A3.t1 a_4263_n2391# GND.t92 sky130_fd_pr__nfet_01v8 ad=0.10025 pd=0.985 as=0.0567 ps=0.69 w=0.42 l=0.15
X89 x5.A1 x2.x4.A VDD.t21 VDD.t20 sky130_fd_pr__pfet_01v8_hvt ad=0.26 pd=2.52 as=0.26 ps=2.52 w=1 l=0.15
X90 GND.t23 x2.x4.A a_5957_n2391# GND.t22 sky130_fd_pr__nfet_01v8 ad=0.10025 pd=0.985 as=0.0567 ps=0.69 w=0.42 l=0.15
X91 P1.t1 a_4903_n1962# GND.t17 GND.t16 sky130_fd_pr__nfet_01v8 ad=0.169 pd=1.82 as=0.11285 ps=1.045 w=0.65 l=0.15
X92 a_4903_n1962# x5.A0 a_4903_n1635# GND.t45 sky130_fd_pr__nfet_01v8 ad=0.09975 pd=0.895 as=0.0693 ps=0.75 w=0.42 l=0.15
X93 GND.t63 A7.t1 a_4264_n1111# GND.t62 sky130_fd_pr__nfet_01v8 ad=0.10025 pd=0.985 as=0.0567 ps=0.69 w=0.42 l=0.15
X94 VDD.t62 A7.t3 a_4346_n1111# VDD.t61 sky130_fd_pr__pfet_01v8_hvt ad=0.14575 pd=1.335 as=0.0441 ps=0.63 w=0.42 l=0.15
X95 x2.x4.A a_4263_n2391# VDD.t18 VDD.t17 sky130_fd_pr__pfet_01v8_hvt ad=0.34 pd=2.68 as=0.14575 ps=1.335 w=1 l=0.15
X96 GND.t31 x1.x4.A a_5958_n1111# GND.t30 sky130_fd_pr__nfet_01v8 ad=0.10025 pd=0.985 as=0.0567 ps=0.69 w=0.42 l=0.15
X97 x3.B a_5957_n2391# GND.t27 GND.t26 sky130_fd_pr__nfet_01v8 ad=0.169 pd=1.82 as=0.10025 ps=0.985 w=0.65 l=0.15
X98 a_5789_n1769# x4.A GND.t7 GND.t6 sky130_fd_pr__nfet_01v8 ad=0.0567 pd=0.69 as=0.10025 ps=0.985 w=0.42 l=0.15
X99 VDD.t29 x1.x4.A a_6040_n1111# VDD.t28 sky130_fd_pr__pfet_01v8_hvt ad=0.14575 pd=1.335 as=0.0441 ps=0.63 w=0.42 l=0.15
X100 GND.t89 A1.t1 a_3359_n2391# GND.t88 sky130_fd_pr__nfet_01v8 ad=0.10025 pd=0.985 as=0.0567 ps=0.69 w=0.42 l=0.15
X101 x4.A a_5958_n1111# GND.t35 GND.t34 sky130_fd_pr__nfet_01v8 ad=0.169 pd=1.82 as=0.10025 ps=0.985 w=0.65 l=0.15
X102 a_4263_n2391# A2.t0 GND.t91 GND.t90 sky130_fd_pr__nfet_01v8 ad=0.0567 pd=0.69 as=0.1092 ps=1.36 w=0.42 l=0.15
X103 x4.A a_5958_n1111# VDD.t33 VDD.t32 sky130_fd_pr__pfet_01v8_hvt ad=0.34 pd=2.68 as=0.14575 ps=1.335 w=1 l=0.15
R0 A2.n0 A2.t0 192.639
R1 A2.n1 A2.n0 152
R2 A2.n0 A2.t1 134.799
R3 A2.n1 A2 9.78757
R4 A2 A2.n1 6.17193
R5 A0.n0 A0.t0 192.639
R6 A0.n1 A0.n0 152
R7 A0.n0 A0.t1 134.799
R8 A0.n1 A0 9.78757
R9 A0 A0.n1 6.17193
R10 A3.n0 A3.t2 230.576
R11 A3.n1 A3.t1 206.19
R12 A3.n0 A3.t0 158.275
R13 A3.n4 A3.n0 152.268
R14 A3.n2 A3.n1 152
R15 A3.n1 A3.t3 148.35
R16 A3.n4 A3.n3 11.0554
R17 A3.n3 A3.n2 10.8751
R18 A3 A3.n4 6.4005
R19 A3.n3 A3 1.19693
R20 A3.n2 A3 0.686214
R21 A1.n0 A1.t2 230.576
R22 A1.n1 A1.t1 206.19
R23 A1.n0 A1.t0 158.275
R24 A1.n4 A1.n0 152.268
R25 A1.n2 A1.n1 152
R26 A1.n1 A1.t3 148.35
R27 A1.n4 A1.n3 11.0554
R28 A1.n3 A1.n2 10.8751
R29 A1 A1.n4 6.4005
R30 A1.n3 A1 1.19693
R31 A1.n2 A1 0.686214
R32 V.n1 V.t0 334.322
R33 V.n0 V.t1 176.903
R34 V.n1 V 21.624
R35 V.n0 V 4.47034
R36 V V.n1 3.63184
R37 V V.n0 2.63228
R38 P1.n2 P1 586.72
R39 P1.n2 P1.n1 585
R40 P1.n3 P1.n2 585
R41 P1 P1.t1 215.947
R42 P1.n1 P1.n0 38.539
R43 P1.n0 P1 28.7208
R44 P1.n2 P1.t0 26.5955
R45 P1.n0 P1 22.4319
R46 P1 P1.n1 11.2721
R47 P1.n3 P1 11.2721
R48 P1 P1.n3 1.7199
R49 P0.n2 P0 586.72
R50 P0.n3 P0.n2 585
R51 P0.n2 P0.n1 585
R52 P0.n0 P0.t1 214.944
R53 P0 P0.n3 68.2971
R54 P0.n2 P0.t0 26.5955
R55 P0.n0 P0 13.7027
R56 P0.n3 P0 11.2721
R57 P0 P0.n1 11.2721
R58 P0.n1 P0 1.7199
R59 P0 P0.n0 1.00442
R60 P2 P2.n0 439.457
R61 P2.n8 P2.n7 406.031
R62 P2.n5 P2.t9 329.902
R63 P2.n1 P2.t7 329.902
R64 P2.n7 P2.t4 272.062
R65 P2.n0 P2.t2 272.062
R66 P2.n4 P2.t0 221.918
R67 P2.n7 P2.t8 206.19
R68 P2.n0 P2.t6 206.19
R69 P2 P2.t1 162.351
R70 P2.n6 P2.n5 152
R71 P2.n2 P2.n1 152
R72 P2.n5 P2.t5 148.35
R73 P2.n1 P2.t3 148.35
R74 P2.n8 P2 33.4271
R75 P2 P2.n6 20.211
R76 P2.n2 P2 20.211
R77 P2.n10 P2.n4 16.2259
R78 P2.n3 P2 11.6875
R79 P2.n6 P2 10.7794
R80 P2.n11 P2.n10 9.609
R81 P2.n9 P2.n8 9.3005
R82 P2.n4 P2 8.5998
R83 P2.n3 P2 7.23528
R84 P2.n11 P2.n2 5.38997
R85 P2 P2.n11 5.38997
R86 P2 P2.n3 5.04292
R87 P2.n10 P2.n9 3.06366
R88 P2.n9 P2 2.06346
R89 A6.n0 A6.t0 192.639
R90 A6.n1 A6.n0 152
R91 A6.n0 A6.t1 134.799
R92 A6.n1 A6 9.78757
R93 A6 A6.n1 6.17193
R94 A4.n0 A4.t0 192.639
R95 A4.n1 A4.n0 152
R96 A4.n0 A4.t1 134.799
R97 A4.n1 A4 9.78757
R98 A4 A4.n1 6.17193
R99 A7.n0 A7.t2 230.576
R100 A7.n1 A7.t1 206.19
R101 A7.n0 A7.t0 158.275
R102 A7.n4 A7.n0 152.268
R103 A7.n2 A7.n1 152
R104 A7.n1 A7.t3 148.35
R105 A7.n4 A7.n3 11.0554
R106 A7.n3 A7.n2 10.8751
R107 A7 A7.n4 6.4005
R108 A7.n3 A7 1.19693
R109 A7.n2 A7 0.686214
R110 A5.n0 A5.t2 230.576
R111 A5.n1 A5.t1 206.19
R112 A5.n0 A5.t0 158.275
R113 A5.n4 A5.n0 152.268
R114 A5.n2 A5.n1 152
R115 A5.n1 A5.t3 148.35
R116 A5.n4 A5.n3 11.0554
R117 A5.n3 A5.n2 10.8751
R118 A5 A5.n4 6.4005
R119 A5.n3 A5 1.19693
R120 A5.n2 A5 0.686214
R121 VDD.t44 VDD.t55 633.333
R122 VDD.n35 VDD.n34 629.801
R123 VDD.n53 VDD.n52 629.801
R124 VDD.n17 VDD.n16 629.801
R125 VDD.n73 VDD.n72 629.801
R126 VDD.n67 VDD.t59 553.428
R127 VDD.n61 VDD.t68 553.428
R128 VDD.t32 VDD 547.509
R129 VDD VDD.t37 547.509
R130 VDD VDD.t34 547.509
R131 VDD.t24 VDD 547.509
R132 VDD.t39 VDD 500.156
R133 VDD.n67 VDD 467.601
R134 VDD VDD.n61 446.885
R135 VDD.t1 VDD.t41 322.587
R136 VDD.n39 VDD.n38 315.303
R137 VDD.n204 VDD.n6 315.303
R138 VDD.n63 VDD.n62 315.303
R139 VDD.n85 VDD.n77 315.303
R140 VDD.n130 VDD.n129 315.303
R141 VDD.n9 VDD.n8 315.301
R142 VDD.n124 VDD.n123 315.301
R143 VDD VDD.t30 313.707
R144 VDD VDD.t56 313.707
R145 VDD.t59 VDD 313.707
R146 VDD.t70 VDD 313.707
R147 VDD.t68 VDD 313.707
R148 VDD.t65 VDD 313.707
R149 VDD.t79 VDD 313.707
R150 VDD VDD.t20 313.707
R151 VDD.t41 VDD.t44 304.829
R152 VDD.t28 VDD.t32 287.072
R153 VDD.t37 VDD.t61 287.072
R154 VDD.t34 VDD.t66 287.072
R155 VDD.t57 VDD.t80 287.072
R156 VDD.t46 VDD.t39 284.113
R157 VDD.t17 VDD 265.483
R158 VDD.t36 VDD.t8 261.178
R159 VDD.n32 VDD.t88 255.905
R160 VDD.n1 VDD.t21 255.905
R161 VDD.n59 VDD.t69 255.905
R162 VDD.n65 VDD.t60 255.905
R163 VDD.n79 VDD.t31 255.905
R164 VDD.n56 VDD.t83 255.905
R165 VDD.n20 VDD.t9 255.904
R166 VDD.n26 VDD.n25 235.248
R167 VDD.n43 VDD.n42 235.248
R168 VDD.n174 VDD.n173 235.248
R169 VDD.n102 VDD.n69 235.248
R170 VDD.n48 VDD 216.692
R171 VDD.n55 VDD.n54 213.119
R172 VDD.n116 VDD.n61 213.119
R173 VDD.n105 VDD.n67 213.119
R174 VDD.n47 VDD.n31 213.119
R175 VDD.n143 VDD.n48 213.119
R176 VDD.t56 VDD.t28 213.084
R177 VDD.t55 VDD.t46 213.084
R178 VDD.t61 VDD.t70 213.084
R179 VDD.t66 VDD.t65 213.084
R180 VDD.t80 VDD.t79 213.084
R181 VDD.n54 VDD.t57 200.451
R182 VDD.n47 VDD.t43 179.381
R183 VDD VDD.t82 152.115
R184 VDD.t63 VDD.t49 137.764
R185 VDD.t73 VDD.t4 137.764
R186 VDD.t22 VDD.t24 134.046
R187 VDD.t49 VDD.t13 130.589
R188 VDD.t48 VDD.n47 127.719
R189 VDD.n173 VDD.t52 123.507
R190 VDD.n69 VDD.t42 123.507
R191 VDD.n25 VDD.t72 123.507
R192 VDD.n42 VDD.t76 123.507
R193 VDD.t13 VDD 111.934
R194 VDD.n54 VDD 106.194
R195 VDD.t6 VDD.t12 103.323
R196 VDD.t53 VDD.t48 103.323
R197 VDD.t4 VDD.t3 103.323
R198 VDD.t77 VDD.t87 100.454
R199 VDD.t85 VDD 100.454
R200 VDD.n8 VDD.t7 96.1553
R201 VDD.n38 VDD.t86 96.1553
R202 VDD.n6 VDD.t23 96.1553
R203 VDD.n123 VDD.t67 96.1553
R204 VDD.n62 VDD.t62 96.1553
R205 VDD.n77 VDD.t29 96.1553
R206 VDD.n129 VDD.t81 96.1553
R207 VDD.n34 VDD.t54 86.7743
R208 VDD.n52 VDD.t5 86.7743
R209 VDD.n16 VDD.t64 86.7743
R210 VDD.n72 VDD.t47 86.7743
R211 VDD.t71 VDD.t51 84.6682
R212 VDD.t19 VDD 81.7981
R213 VDD.t45 VDD.t84 80.363
R214 VDD.t15 VDD.t36 76.0579
R215 VDD.t26 VDD.t71 71.7528
R216 VDD VDD.t45 71.7528
R217 VDD.n34 VDD.t78 68.0124
R218 VDD.n52 VDD.t74 68.0124
R219 VDD.n16 VDD.t50 68.0124
R220 VDD.n72 VDD.t40 68.0124
R221 VDD.t84 VDD.t75 67.4476
R222 VDD VDD.t1 59.1905
R223 VDD.t0 VDD 57.4023
R224 VDD.t51 VDD 51.6621
R225 VDD VDD.t77 51.6621
R226 VDD.t43 VDD 47.357
R227 VDD VDD.t63 45.9219
R228 VDD.t8 VDD.t0 45.9219
R229 VDD.n202 VDD.n201 43.9358
R230 VDD.n150 VDD.n149 43.9358
R231 VDD.n175 VDD.n174 43.1829
R232 VDD.n103 VDD.n102 43.1829
R233 VDD.t87 VDD.t53 37.3117
R234 VDD.t75 VDD.t85 35.8766
R235 VDD.n194 VDD.n193 34.6358
R236 VDD.n193 VDD.n14 34.6358
R237 VDD.n186 VDD.n185 34.6358
R238 VDD.n185 VDD.n21 34.6358
R239 VDD.n178 VDD.n177 34.6358
R240 VDD.n177 VDD.n27 34.6358
R241 VDD.n170 VDD.n27 34.6358
R242 VDD.n170 VDD.n169 34.6358
R243 VDD.n169 VDD.n29 34.6358
R244 VDD.n162 VDD.n161 34.6358
R245 VDD.n161 VDD.n36 34.6358
R246 VDD.n154 VDD.n153 34.6358
R247 VDD.n153 VDD.n44 34.6358
R248 VDD.n147 VDD.n44 34.6358
R249 VDD.n147 VDD.n146 34.6358
R250 VDD.n146 VDD.n46 34.6358
R251 VDD.n139 VDD.n138 34.6358
R252 VDD.n158 VDD.n37 34.6358
R253 VDD.n158 VDD.n157 34.6358
R254 VDD.n166 VDD.n165 34.6358
R255 VDD.n206 VDD.n4 34.6358
R256 VDD.n206 VDD.n205 34.6358
R257 VDD.n198 VDD.n5 34.6358
R258 VDD.n198 VDD.n197 34.6358
R259 VDD.n197 VDD.n11 34.6358
R260 VDD.n190 VDD.n189 34.6358
R261 VDD.n189 VDD.n18 34.6358
R262 VDD.n182 VDD.n18 34.6358
R263 VDD.n182 VDD.n181 34.6358
R264 VDD.n181 VDD.n23 34.6358
R265 VDD.n126 VDD.n121 34.6358
R266 VDD.n126 VDD.n125 34.6358
R267 VDD.n118 VDD.n117 34.6358
R268 VDD.n111 VDD.n110 34.6358
R269 VDD.n112 VDD.n111 34.6358
R270 VDD.n107 VDD.n106 34.6358
R271 VDD.n89 VDD.n75 34.6358
R272 VDD.n90 VDD.n89 34.6358
R273 VDD.n91 VDD.n90 34.6358
R274 VDD.n95 VDD.n94 34.6358
R275 VDD.n96 VDD.n95 34.6358
R276 VDD.n96 VDD.n70 34.6358
R277 VDD.n100 VDD.n70 34.6358
R278 VDD.n101 VDD.n100 34.6358
R279 VDD.n83 VDD.n78 34.6358
R280 VDD.n84 VDD.n83 34.6358
R281 VDD.n142 VDD.n49 34.6358
R282 VDD.n135 VDD.n134 34.6358
R283 VDD.n134 VDD.n57 34.6358
R284 VDD.n201 VDD.n9 34.2593
R285 VDD.n150 VDD.n39 34.2593
R286 VDD.n204 VDD.n5 34.2593
R287 VDD.n85 VDD.n75 34.2593
R288 VDD.n26 VDD.n21 33.8829
R289 VDD.n43 VDD.n36 33.8829
R290 VDD.n25 VDD.t16 28.752
R291 VDD.n42 VDD.t11 28.752
R292 VDD.n173 VDD.t27 28.752
R293 VDD.n69 VDD.t2 28.752
R294 VDD VDD.t26 28.7014
R295 VDD VDD.t6 27.2664
R296 VDD.n8 VDD.t14 25.6105
R297 VDD.n38 VDD.t18 25.6105
R298 VDD.n6 VDD.t25 25.6105
R299 VDD.n123 VDD.t35 25.6105
R300 VDD.n62 VDD.t38 25.6105
R301 VDD.n77 VDD.t33 25.6105
R302 VDD.n129 VDD.t58 25.6105
R303 VDD.n138 VDD.n55 23.7181
R304 VDD.n166 VDD.n31 23.7181
R305 VDD.n117 VDD.n116 23.7181
R306 VDD.n106 VDD.n105 23.7181
R307 VDD.n143 VDD.n142 23.7181
R308 VDD VDD.t22 21.5262
R309 VDD.t12 VDD.t19 21.5262
R310 VDD VDD.t15 20.0911
R311 VDD VDD.t10 20.0911
R312 VDD.t10 VDD.t17 18.6561
R313 VDD.t3 VDD.n48 18.6561
R314 VDD.n2 VDD.n1 18.2003
R315 VDD.n80 VDD.n79 18.2003
R316 VDD.n35 VDD.n29 17.3181
R317 VDD.n162 VDD.n35 17.3181
R318 VDD.n53 VDD.n46 17.3181
R319 VDD.n139 VDD.n53 17.3181
R320 VDD.n17 VDD.n11 17.3181
R321 VDD.n190 VDD.n17 17.3181
R322 VDD.n91 VDD.n73 17.3181
R323 VDD.n94 VDD.n73 17.3181
R324 VDD.n186 VDD.n20 10.5417
R325 VDD.n165 VDD.n32 10.5417
R326 VDD.n118 VDD.n59 10.5417
R327 VDD.n107 VDD.n65 10.5417
R328 VDD.n56 VDD.n49 10.5417
R329 VDD.n194 VDD.n9 10.1652
R330 VDD.n157 VDD.n39 10.1652
R331 VDD.n205 VDD.n204 10.1652
R332 VDD.n125 VDD.n124 10.1652
R333 VDD.n112 VDD.n63 10.1652
R334 VDD.n85 VDD.n84 10.1652
R335 VDD.n130 VDD.n57 10.1652
R336 VDD.n81 VDD.n78 9.3005
R337 VDD.n83 VDD.n82 9.3005
R338 VDD.n84 VDD.n76 9.3005
R339 VDD.n86 VDD.n85 9.3005
R340 VDD.n87 VDD.n75 9.3005
R341 VDD.n89 VDD.n88 9.3005
R342 VDD.n90 VDD.n74 9.3005
R343 VDD.n92 VDD.n91 9.3005
R344 VDD.n94 VDD.n93 9.3005
R345 VDD.n95 VDD.n71 9.3005
R346 VDD.n97 VDD.n96 9.3005
R347 VDD.n98 VDD.n70 9.3005
R348 VDD.n100 VDD.n99 9.3005
R349 VDD.n101 VDD.n68 9.3005
R350 VDD.n105 VDD.n104 9.3005
R351 VDD.n106 VDD.n66 9.3005
R352 VDD.n108 VDD.n107 9.3005
R353 VDD.n110 VDD.n109 9.3005
R354 VDD.n111 VDD.n64 9.3005
R355 VDD.n113 VDD.n112 9.3005
R356 VDD.n116 VDD.n115 9.3005
R357 VDD.n117 VDD.n60 9.3005
R358 VDD.n119 VDD.n118 9.3005
R359 VDD.n121 VDD.n120 9.3005
R360 VDD.n127 VDD.n126 9.3005
R361 VDD.n125 VDD.n58 9.3005
R362 VDD.n132 VDD.n57 9.3005
R363 VDD.n204 VDD.n203 9.3005
R364 VDD.n10 VDD.n5 9.3005
R365 VDD.n199 VDD.n198 9.3005
R366 VDD.n197 VDD.n196 9.3005
R367 VDD.n13 VDD.n11 9.3005
R368 VDD.n191 VDD.n190 9.3005
R369 VDD.n189 VDD.n188 9.3005
R370 VDD.n19 VDD.n18 9.3005
R371 VDD.n183 VDD.n182 9.3005
R372 VDD.n181 VDD.n180 9.3005
R373 VDD.n24 VDD.n23 9.3005
R374 VDD.n31 VDD.n28 9.3005
R375 VDD.n167 VDD.n166 9.3005
R376 VDD.n165 VDD.n164 9.3005
R377 VDD.n37 VDD.n33 9.3005
R378 VDD.n159 VDD.n158 9.3005
R379 VDD.n157 VDD.n156 9.3005
R380 VDD.n41 VDD.n39 9.3005
R381 VDD.n151 VDD.n150 9.3005
R382 VDD.n144 VDD.n143 9.3005
R383 VDD.n142 VDD.n141 9.3005
R384 VDD.n51 VDD.n49 9.3005
R385 VDD.n136 VDD.n135 9.3005
R386 VDD.n134 VDD.n133 9.3005
R387 VDD.n128 VDD.n55 9.3005
R388 VDD.n201 VDD.n200 9.3005
R389 VDD.n12 VDD.n9 9.3005
R390 VDD.n195 VDD.n194 9.3005
R391 VDD.n193 VDD.n192 9.3005
R392 VDD.n15 VDD.n14 9.3005
R393 VDD.n187 VDD.n186 9.3005
R394 VDD.n185 VDD.n184 9.3005
R395 VDD.n22 VDD.n21 9.3005
R396 VDD.n179 VDD.n178 9.3005
R397 VDD.n177 VDD.n176 9.3005
R398 VDD.n172 VDD.n27 9.3005
R399 VDD.n171 VDD.n170 9.3005
R400 VDD.n169 VDD.n168 9.3005
R401 VDD.n30 VDD.n29 9.3005
R402 VDD.n163 VDD.n162 9.3005
R403 VDD.n161 VDD.n160 9.3005
R404 VDD.n40 VDD.n36 9.3005
R405 VDD.n155 VDD.n154 9.3005
R406 VDD.n153 VDD.n152 9.3005
R407 VDD.n45 VDD.n44 9.3005
R408 VDD.n148 VDD.n147 9.3005
R409 VDD.n146 VDD.n145 9.3005
R410 VDD.n50 VDD.n46 9.3005
R411 VDD.n140 VDD.n139 9.3005
R412 VDD.n138 VDD.n137 9.3005
R413 VDD.n4 VDD.n3 9.3005
R414 VDD.n207 VDD.n206 9.3005
R415 VDD.n205 VDD.n0 9.3005
R416 VDD.t82 VDD.t73 8.61077
R417 VDD.n20 VDD.n14 8.28285
R418 VDD.n37 VDD.n32 8.28285
R419 VDD.n4 VDD.n1 8.28285
R420 VDD.n121 VDD.n59 8.28285
R421 VDD.n110 VDD.n65 8.28285
R422 VDD.n79 VDD.n78 8.28285
R423 VDD.n135 VDD.n56 8.28285
R424 VDD.n114 VDD.n63 7.5914
R425 VDD.n124 VDD.n122 7.5914
R426 VDD.n131 VDD.n130 7.5914
R427 VDD.n178 VDD.n26 0.753441
R428 VDD.n154 VDD.n43 0.753441
R429 VDD.n174 VDD.n23 0.753441
R430 VDD.n102 VDD.n101 0.753441
R431 VDD.n7 VDD 0.332531
R432 VDD VDD.n114 0.237498
R433 VDD.n122 VDD 0.237498
R434 VDD.n131 VDD 0.237498
R435 VDD.n2 VDD 0.163445
R436 VDD.n80 VDD 0.159538
R437 VDD.n114 VDD.n113 0.146355
R438 VDD.n122 VDD.n58 0.146355
R439 VDD.n132 VDD.n131 0.146355
R440 VDD.n81 VDD.n80 0.141672
R441 VDD.n3 VDD.n2 0.141672
R442 VDD.n82 VDD.n76 0.120292
R443 VDD.n86 VDD.n76 0.120292
R444 VDD.n87 VDD.n86 0.120292
R445 VDD.n88 VDD.n87 0.120292
R446 VDD.n92 VDD.n74 0.120292
R447 VDD.n93 VDD.n92 0.120292
R448 VDD.n93 VDD.n71 0.120292
R449 VDD.n97 VDD.n71 0.120292
R450 VDD.n98 VDD.n97 0.120292
R451 VDD.n99 VDD.n98 0.120292
R452 VDD.n99 VDD.n68 0.120292
R453 VDD.n103 VDD.n68 0.120292
R454 VDD.n108 VDD.n66 0.120292
R455 VDD.n109 VDD.n108 0.120292
R456 VDD.n113 VDD.n64 0.120292
R457 VDD.n119 VDD.n60 0.120292
R458 VDD.n120 VDD.n119 0.120292
R459 VDD.n127 VDD.n58 0.120292
R460 VDD.n207 VDD.n0 0.120292
R461 VDD.n7 VDD.n0 0.0877396
R462 VDD VDD.n132 0.0616979
R463 VDD.n82 VDD 0.0603958
R464 VDD VDD.n74 0.0603958
R465 VDD.n104 VDD 0.0603958
R466 VDD VDD.n66 0.0603958
R467 VDD VDD.n64 0.0603958
R468 VDD.n115 VDD 0.0603958
R469 VDD VDD.n60 0.0603958
R470 VDD VDD.n127 0.0603958
R471 VDD VDD.n207 0.0603958
R472 VDD.n141 VDD.n140 0.0597448
R473 VDD.n137 VDD.n51 0.0597448
R474 VDD.n167 VDD.n30 0.0493281
R475 VDD.n164 VDD.n163 0.0493281
R476 VDD.n152 VDD.n41 0.0493281
R477 VDD.n151 VDD.n45 0.0493281
R478 VDD VDD.n155 0.0486771
R479 VDD.n200 VDD.n199 0.046724
R480 VDD.n195 VDD.n13 0.046724
R481 VDD.n187 VDD.n19 0.046724
R482 VDD.n179 VDD.n24 0.046724
R483 VDD.n176 VDD.n175 0.046724
R484 VDD.n10 VDD 0.0356562
R485 VDD.n188 VDD 0.0356562
R486 VDD.n180 VDD 0.0350052
R487 VDD.n104 VDD 0.03175
R488 VDD.n115 VDD 0.03175
R489 VDD.n196 VDD 0.0304479
R490 VDD.n192 VDD 0.0304479
R491 VDD.n184 VDD 0.0304479
R492 VDD.n40 VDD 0.0304479
R493 VDD.n145 VDD 0.0297969
R494 VDD.n50 VDD 0.0297969
R495 VDD.n128 VDD 0.0297969
R496 VDD VDD.n81 0.0226354
R497 VDD.n88 VDD 0.0226354
R498 VDD.n109 VDD 0.0226354
R499 VDD.n120 VDD 0.0226354
R500 VDD.n3 VDD 0.0226354
R501 VDD VDD.n103 0.0213333
R502 VDD VDD.n171 0.0193802
R503 VDD.n168 VDD 0.0193802
R504 VDD.n160 VDD 0.0193802
R505 VDD.n159 VDD 0.0193802
R506 VDD VDD.n148 0.0193802
R507 VDD.n133 VDD 0.0187292
R508 VDD.n203 VDD.n7 0.016776
R509 VDD VDD.n12 0.016776
R510 VDD VDD.n191 0.016776
R511 VDD VDD.n183 0.016776
R512 VDD.n172 VDD 0.016776
R513 VDD VDD.n28 0.016125
R514 VDD.n144 VDD 0.016125
R515 VDD.n203 VDD.n202 0.0141719
R516 VDD.n200 VDD.n10 0.0141719
R517 VDD.n196 VDD.n195 0.0141719
R518 VDD.n192 VDD.n13 0.0141719
R519 VDD.n191 VDD.n15 0.0141719
R520 VDD.n188 VDD.n187 0.0141719
R521 VDD.n184 VDD.n19 0.0141719
R522 VDD.n183 VDD.n22 0.0141719
R523 VDD.n180 VDD.n179 0.0141719
R524 VDD.n176 VDD.n24 0.0141719
R525 VDD VDD.n22 0.0122188
R526 VDD.n202 VDD 0.0115677
R527 VDD.n199 VDD 0.0115677
R528 VDD VDD.n15 0.0115677
R529 VDD.n171 VDD.n28 0.0115677
R530 VDD.n168 VDD.n167 0.0115677
R531 VDD.n164 VDD.n30 0.0115677
R532 VDD.n163 VDD.n33 0.0115677
R533 VDD VDD.n33 0.0115677
R534 VDD.n160 VDD.n159 0.0115677
R535 VDD.n156 VDD.n40 0.0115677
R536 VDD.n155 VDD.n41 0.0115677
R537 VDD.n152 VDD.n151 0.0115677
R538 VDD.n149 VDD.n45 0.0115677
R539 VDD.n149 VDD 0.0115677
R540 VDD.n136 VDD 0.0115677
R541 VDD.n175 VDD 0.0109167
R542 VDD.n148 VDD 0.00635938
R543 VDD VDD.n172 0.00375521
R544 VDD.n12 VDD 0.00310417
R545 VDD.n156 VDD 0.00115104
R546 VDD.n145 VDD.n144 0.00115104
R547 VDD.n141 VDD.n50 0.00115104
R548 VDD.n140 VDD.n51 0.00115104
R549 VDD.n137 VDD.n136 0.00115104
R550 VDD.n133 VDD.n128 0.00115104
R551 GND GND.n119 2.9217e+06
R552 GND.n119 GND.t24 11633.7
R553 GND.n13 GND.t94 2662.78
R554 GND.n6 GND.t86 2662.78
R555 GND GND.t26 2634.3
R556 GND GND.t18 2634.3
R557 GND GND.t60 2634.3
R558 GND GND.t53 2406.47
R559 GND.t53 GND.t66 2392.23
R560 GND GND.n13 2392.23
R561 GND GND.n6 2150.16
R562 GND.t38 GND.t0 1779.94
R563 GND.t51 GND.t28 1552.1
R564 GND.t24 GND 1509.39
R565 GND.t94 GND 1509.39
R566 GND.t86 GND 1509.39
R567 GND.t26 GND.t22 1381.23
R568 GND.t18 GND.t92 1381.23
R569 GND.t60 GND.t88 1381.23
R570 GND.t66 GND.t38 1366.99
R571 GND.t0 GND.t51 1366.99
R572 GND.t20 GND 1338.51
R573 GND.t90 GND 1338.51
R574 GND.t84 GND 1338.51
R575 GND GND.t39 1317.15
R576 GND.n119 GND.t32 1229.61
R577 GND.n141 GND.n140 1198.25
R578 GND.n143 GND.n142 1198.25
R579 GND.n217 GND.n6 1198.25
R580 GND.n202 GND.n13 1198.25
R581 GND.n122 GND.n120 1198.25
R582 GND.t22 GND.t20 1196.12
R583 GND.t92 GND.t90 1196.12
R584 GND.t88 GND.t84 1196.12
R585 GND.t78 GND.t4 1196.12
R586 GND.t43 GND 918.447
R587 GND.t46 GND.t57 889.968
R588 GND.t50 GND.t45 889.968
R589 GND GND.t34 848.802
R590 GND.n120 GND.t36 783.173
R591 GND GND.t72 754.693
R592 GND.t55 GND.t64 690.615
R593 GND.t36 GND.t70 690.615
R594 GND.t68 GND 669.256
R595 GND.t14 GND.t43 640.778
R596 GND.n142 GND.t55 640.778
R597 GND.t34 GND.t30 638.659
R598 GND.t70 GND.t68 598.058
R599 GND.t47 GND.n141 583.819
R600 GND GND.t14 562.461
R601 GND.t58 GND.t6 541.101
R602 GND.n120 GND 533.981
R603 GND.t64 GND.t82 505.502
R604 GND GND.t47 491.262
R605 GND.t32 GND 486.341
R606 GND.t8 GND.t46 448.545
R607 GND GND.t12 427.185
R608 GND.t41 GND.t80 427.185
R609 GND GND.t62 420.065
R610 GND.t76 GND.t74 412.945
R611 GND.t3 GND 398.707
R612 GND.t80 GND.t1 348.868
R613 GND.t57 GND.t16 334.628
R614 GND GND.t48 277.671
R615 GND.t74 GND.t3 270.55
R616 GND GND.t50 263.43
R617 GND.t82 GND 249.191
R618 GND.n229 GND.t85 246.506
R619 GND.n214 GND.t91 246.506
R620 GND.n182 GND.t21 246.506
R621 GND.n127 GND.t69 246.506
R622 GND.n106 GND.t75 246.506
R623 GND.n41 GND.t59 246.506
R624 GND.n43 GND.t13 246.506
R625 GND.t48 GND.t8 234.952
R626 GND.n2 GND.n1 210.601
R627 GND.n9 GND.n8 210.601
R628 GND.n21 GND.n20 210.601
R629 GND.n125 GND.n124 210.601
R630 GND.n96 GND.n95 210.601
R631 GND.n40 GND.n39 210.601
R632 GND.n45 GND.n44 210.601
R633 GND.n199 GND.n198 199.739
R634 GND.n150 GND.n63 199.739
R635 GND.n101 GND.n75 199.739
R636 GND.n60 GND.n59 199.739
R637 GND.t62 GND.t76 185.113
R638 GND.n191 GND.n190 185
R639 GND.n189 GND.n188 185
R640 GND.n56 GND.n55 185
R641 GND.n54 GND.n48 185
R642 GND.n115 GND.n114 185
R643 GND.n113 GND.n112 185
R644 GND.n88 GND.n87 185
R645 GND.n86 GND.n85 185
R646 GND GND.t41 177.994
R647 GND.t16 GND 170.875
R648 GND.t10 GND 170.875
R649 GND.n4 GND.t87 158.361
R650 GND.n11 GND.t95 158.361
R651 GND.n23 GND.t25 158.361
R652 GND.n135 GND.t73 158.361
R653 GND.n78 GND.t65 158.361
R654 GND.n33 GND.t33 158.361
R655 GND.n50 GND.t9 158.361
R656 GND.t28 GND 142.395
R657 GND.t6 GND 128.155
R658 GND.t30 GND 113.916
R659 GND.t39 GND.t10 99.6769
R660 GND.n141 GND.t4 99.6769
R661 GND.n190 GND.n189 97.1434
R662 GND.n55 GND.n54 97.1434
R663 GND.n87 GND.n86 97.1434
R664 GND.n114 GND.n113 97.1434
R665 GND.n198 GND.t52 74.2862
R666 GND.n63 GND.t42 74.2862
R667 GND.n75 GND.t77 74.2862
R668 GND.n59 GND.t81 74.2862
R669 GND.t1 GND 71.1979
R670 GND.n190 GND.t67 61.4291
R671 GND.n55 GND.t49 61.4291
R672 GND.n86 GND.t56 61.4291
R673 GND.n113 GND.t5 61.4291
R674 GND.t12 GND.t58 56.9584
R675 GND.n1 GND.t89 55.7148
R676 GND.n8 GND.t93 55.7148
R677 GND.n20 GND.t23 55.7148
R678 GND.n124 GND.t71 55.7148
R679 GND.n95 GND.t63 55.7148
R680 GND.n39 GND.t31 55.7148
R681 GND.n44 GND.t7 55.7148
R682 GND.n142 GND.t45 42.7189
R683 GND.n189 GND.t54 38.5719
R684 GND.n54 GND.t44 38.5719
R685 GND.n87 GND.t83 38.5719
R686 GND.n114 GND.t79 38.5719
R687 GND.t72 GND.t78 35.5992
R688 GND.n219 GND.n218 34.6358
R689 GND.n223 GND.n222 34.6358
R690 GND.n224 GND.n223 34.6358
R691 GND.n228 GND.n227 34.6358
R692 GND.n204 GND.n203 34.6358
R693 GND.n208 GND.n207 34.6358
R694 GND.n209 GND.n208 34.6358
R695 GND.n213 GND.n212 34.6358
R696 GND.n27 GND.n26 34.6358
R697 GND.n28 GND.n27 34.6358
R698 GND.n181 GND.n180 34.6358
R699 GND.n183 GND.n18 34.6358
R700 GND.n187 GND.n18 34.6358
R701 GND.n192 GND.n15 34.6358
R702 GND.n196 GND.n15 34.6358
R703 GND.n197 GND.n196 34.6358
R704 GND.n136 GND.n69 34.6358
R705 GND.n134 GND.n133 34.6358
R706 GND.n133 GND.n118 34.6358
R707 GND.n129 GND.n128 34.6358
R708 GND.n79 GND.n68 34.6358
R709 GND.n94 GND.n77 34.6358
R710 GND.n97 GND.n94 34.6358
R711 GND.n105 GND.n72 34.6358
R712 GND.n37 GND.n32 34.6358
R713 GND.n38 GND.n37 34.6358
R714 GND.n175 GND.n174 34.6358
R715 GND.n167 GND.n47 34.6358
R716 GND.n167 GND.n166 34.6358
R717 GND.n159 GND.n158 34.6358
R718 GND.n158 GND.n57 34.6358
R719 GND.n151 GND.n57 34.6358
R720 GND.n121 GND.n116 34.6358
R721 GND.n102 GND.n70 34.6358
R722 GND.n109 GND.n70 34.6358
R723 GND.n110 GND.n109 34.6358
R724 GND.n89 GND.n76 34.6358
R725 GND.n100 GND.n76 34.6358
R726 GND.n147 GND.n66 34.6358
R727 GND.n147 GND.n146 34.6358
R728 GND.n146 GND.n67 34.6358
R729 GND.n155 GND.n58 34.6358
R730 GND.n155 GND.n154 34.6358
R731 GND.n163 GND.n49 34.6358
R732 GND.n163 GND.n162 34.6358
R733 GND.n171 GND.n170 34.6358
R734 GND.n150 GND.n149 30.7593
R735 GND.n1 GND.t61 26.8576
R736 GND.n8 GND.t19 26.8576
R737 GND.n20 GND.t27 26.8576
R738 GND.n124 GND.t37 26.8576
R739 GND.n95 GND.t40 26.8576
R740 GND.n39 GND.t35 26.8576
R741 GND.n44 GND.t15 26.8576
R742 GND.n198 GND.t29 25.4291
R743 GND.n63 GND.t2 25.4291
R744 GND.n75 GND.t11 25.4291
R745 GND.n59 GND.t17 25.4291
R746 GND.n218 GND.n217 23.7181
R747 GND.n203 GND.n202 23.7181
R748 GND.n140 GND.n69 23.7181
R749 GND.n143 GND.n68 23.7181
R750 GND.n122 GND.n121 23.7181
R751 GND.n199 GND.n197 22.9652
R752 GND.n151 GND.n150 22.9652
R753 GND.n102 GND.n101 22.9652
R754 GND.n66 GND.n60 22.9652
R755 GND.n192 GND.n191 22.2496
R756 GND.n159 GND.n56 22.2496
R757 GND.n112 GND.n110 22.2496
R758 GND.n85 GND.n67 22.2496
R759 GND.n101 GND.n100 21.4593
R760 GND.n154 GND.n60 21.4593
R761 GND.n34 GND.n33 18.2089
R762 GND.n24 GND.n23 18.2003
R763 GND.n178 GND.n177 16.5836
R764 GND.n224 GND.n2 16.1887
R765 GND.n209 GND.n9 16.1887
R766 GND.n28 GND.n21 16.1887
R767 GND.n125 GND.n118 16.1887
R768 GND.n97 GND.n96 16.1887
R769 GND.n40 GND.n38 16.1887
R770 GND.n49 GND.n45 16.1887
R771 GND.n229 GND.n228 15.0593
R772 GND.n214 GND.n213 15.0593
R773 GND.n182 GND.n181 15.0593
R774 GND.n128 GND.n127 15.0593
R775 GND.n106 GND.n105 15.0593
R776 GND.n174 GND.n41 15.0593
R777 GND.n171 GND.n43 15.0593
R778 GND.n188 GND.n187 11.7085
R779 GND.n166 GND.n48 11.7085
R780 GND.n116 GND.n115 11.7085
R781 GND.n89 GND.n88 11.7085
R782 GND.n230 GND.n229 10.8064
R783 GND.n215 GND.n214 10.8064
R784 GND.n127 GND.n126 10.8064
R785 GND.n107 GND.n106 10.8064
R786 GND.n43 GND.n31 10.8064
R787 GND.n219 GND.n4 10.5417
R788 GND.n204 GND.n11 10.5417
R789 GND.n136 GND.n135 10.5417
R790 GND.n79 GND.n78 10.5417
R791 GND.n58 GND.n50 10.5417
R792 GND.n172 GND.n171 9.3005
R793 GND.n170 GND.n169 9.3005
R794 GND.n49 GND.n46 9.3005
R795 GND.n164 GND.n163 9.3005
R796 GND.n162 GND.n161 9.3005
R797 GND.n58 GND.n52 9.3005
R798 GND.n156 GND.n155 9.3005
R799 GND.n154 GND.n153 9.3005
R800 GND.n62 GND.n60 9.3005
R801 GND.n66 GND.n65 9.3005
R802 GND.n148 GND.n147 9.3005
R803 GND.n146 GND.n145 9.3005
R804 GND.n81 GND.n67 9.3005
R805 GND.n84 GND.n83 9.3005
R806 GND.n90 GND.n89 9.3005
R807 GND.n92 GND.n76 9.3005
R808 GND.n100 GND.n99 9.3005
R809 GND.n101 GND.n74 9.3005
R810 GND.n103 GND.n102 9.3005
R811 GND.n71 GND.n70 9.3005
R812 GND.n109 GND.n108 9.3005
R813 GND.n139 GND.n110 9.3005
R814 GND.n138 GND.n111 9.3005
R815 GND.n137 GND.n116 9.3005
R816 GND.n121 GND.n117 9.3005
R817 GND.n132 GND.n122 9.3005
R818 GND.n150 GND.n64 9.3005
R819 GND.n152 GND.n151 9.3005
R820 GND.n61 GND.n57 9.3005
R821 GND.n158 GND.n157 9.3005
R822 GND.n160 GND.n159 9.3005
R823 GND.n53 GND.n51 9.3005
R824 GND.n166 GND.n165 9.3005
R825 GND.n168 GND.n167 9.3005
R826 GND.n47 GND.n42 9.3005
R827 GND.n174 GND.n173 9.3005
R828 GND.n176 GND.n175 9.3005
R829 GND.n38 GND.n30 9.3005
R830 GND.n37 GND.n36 9.3005
R831 GND.n35 GND.n32 9.3005
R832 GND.n105 GND.n104 9.3005
R833 GND.n73 GND.n72 9.3005
R834 GND.n98 GND.n97 9.3005
R835 GND.n94 GND.n93 9.3005
R836 GND.n91 GND.n77 9.3005
R837 GND.n144 GND.n143 9.3005
R838 GND.n82 GND.n68 9.3005
R839 GND.n80 GND.n79 9.3005
R840 GND.n128 GND.n123 9.3005
R841 GND.n130 GND.n129 9.3005
R842 GND.n131 GND.n118 9.3005
R843 GND.n133 GND.n132 9.3005
R844 GND.n134 GND.n117 9.3005
R845 GND.n140 GND.n139 9.3005
R846 GND.n138 GND.n69 9.3005
R847 GND.n137 GND.n136 9.3005
R848 GND.n197 GND.n14 9.3005
R849 GND.n196 GND.n195 9.3005
R850 GND.n194 GND.n15 9.3005
R851 GND.n193 GND.n192 9.3005
R852 GND.n17 GND.n16 9.3005
R853 GND.n187 GND.n186 9.3005
R854 GND.n185 GND.n18 9.3005
R855 GND.n184 GND.n183 9.3005
R856 GND.n181 GND.n19 9.3005
R857 GND.n180 GND.n179 9.3005
R858 GND.n29 GND.n28 9.3005
R859 GND.n27 GND.n22 9.3005
R860 GND.n26 GND.n25 9.3005
R861 GND.n213 GND.n7 9.3005
R862 GND.n212 GND.n211 9.3005
R863 GND.n210 GND.n209 9.3005
R864 GND.n208 GND.n10 9.3005
R865 GND.n207 GND.n206 9.3005
R866 GND.n202 GND.n201 9.3005
R867 GND.n203 GND.n12 9.3005
R868 GND.n205 GND.n204 9.3005
R869 GND.n228 GND.n0 9.3005
R870 GND.n227 GND.n226 9.3005
R871 GND.n225 GND.n224 9.3005
R872 GND.n223 GND.n3 9.3005
R873 GND.n222 GND.n221 9.3005
R874 GND.n217 GND.n216 9.3005
R875 GND.n218 GND.n5 9.3005
R876 GND.n220 GND.n219 9.3005
R877 GND.n200 GND.n199 7.12063
R878 GND.n222 GND.n4 6.77697
R879 GND.n207 GND.n11 6.77697
R880 GND.n26 GND.n23 6.77697
R881 GND.n135 GND.n134 6.77697
R882 GND.n78 GND.n77 6.77697
R883 GND.n33 GND.n32 6.77697
R884 GND.n162 GND.n50 6.77697
R885 GND.n188 GND.n17 4.35795
R886 GND.n53 GND.n48 4.35795
R887 GND.n115 GND.n111 4.35795
R888 GND.n88 GND.n84 4.35795
R889 GND.n227 GND.n2 2.25932
R890 GND.n212 GND.n9 2.25932
R891 GND.n180 GND.n21 2.25932
R892 GND.n129 GND.n125 2.25932
R893 GND.n96 GND.n72 2.25932
R894 GND.n175 GND.n40 2.25932
R895 GND.n170 GND.n45 2.25932
R896 GND.n191 GND.n17 1.8161
R897 GND.n56 GND.n53 1.8161
R898 GND.n112 GND.n111 1.8161
R899 GND.n85 GND.n84 1.8161
R900 GND.n183 GND.n182 1.50638
R901 GND.n47 GND.n41 1.50638
R902 GND.n24 GND 0.159538
R903 GND.n200 GND.n14 0.148519
R904 GND.n25 GND.n24 0.141672
R905 GND.n29 GND.n22 0.120292
R906 GND.n179 GND.n19 0.120292
R907 GND.n184 GND.n19 0.120292
R908 GND.n186 GND.n185 0.120292
R909 GND.n186 GND.n16 0.120292
R910 GND.n193 GND.n16 0.120292
R911 GND.n194 GND.n193 0.120292
R912 GND.n195 GND.n194 0.120292
R913 GND.n195 GND.n14 0.120292
R914 GND.n205 GND.n12 0.120292
R915 GND.n206 GND.n205 0.120292
R916 GND.n210 GND.n10 0.120292
R917 GND.n211 GND.n210 0.120292
R918 GND.n211 GND.n7 0.120292
R919 GND.n215 GND.n7 0.120292
R920 GND.n220 GND.n5 0.120292
R921 GND.n221 GND.n220 0.120292
R922 GND.n225 GND.n3 0.120292
R923 GND.n226 GND.n225 0.120292
R924 GND.n226 GND.n0 0.120292
R925 GND.n230 GND.n0 0.120292
R926 GND GND.n200 0.11354
R927 GND.n34 GND 0.0803246
R928 GND.n178 GND.n29 0.0773229
R929 GND.n35 GND.n34 0.0713476
R930 GND.n36 GND.n30 0.0603958
R931 GND.n138 GND.n137 0.0603958
R932 GND.n137 GND.n117 0.0603958
R933 GND.n131 GND.n130 0.0603958
R934 GND.n130 GND.n123 0.0603958
R935 GND.n126 GND.n123 0.0603958
R936 GND GND.n22 0.0603958
R937 GND.n185 GND 0.0603958
R938 GND.n201 GND 0.0603958
R939 GND GND.n12 0.0603958
R940 GND GND.n10 0.0603958
R941 GND.n216 GND 0.0603958
R942 GND GND.n5 0.0603958
R943 GND GND.n3 0.0603958
R944 GND.n83 GND.n82 0.0499792
R945 GND.n90 GND.n80 0.0499792
R946 GND.n103 GND.n73 0.0499792
R947 GND.n104 GND.n71 0.0499792
R948 GND GND.n74 0.0486771
R949 GND.n172 GND.n42 0.0460729
R950 GND.n165 GND.n46 0.0460729
R951 GND.n157 GND.n52 0.0460729
R952 GND.n64 GND.n62 0.0460729
R953 GND.n149 GND.n65 0.0460729
R954 GND.n179 GND.n178 0.0434688
R955 GND.n177 GND.n30 0.0395625
R956 GND.n173 GND 0.0350052
R957 GND GND.n160 0.0350052
R958 GND GND.n152 0.0343542
R959 GND.n201 GND 0.0330521
R960 GND.n216 GND 0.0330521
R961 GND.n36 GND 0.0304479
R962 GND GND.n168 0.0304479
R963 GND.n164 GND 0.0304479
R964 GND.n156 GND 0.0304479
R965 GND.n99 GND 0.0304479
R966 GND.n139 GND 0.0304479
R967 GND GND.n138 0.0304479
R968 GND.n132 GND 0.0304479
R969 GND GND.n131 0.0304479
R970 GND.n25 GND 0.0226354
R971 GND GND.n184 0.0226354
R972 GND.n206 GND 0.0226354
R973 GND GND.n215 0.0226354
R974 GND.n221 GND 0.0226354
R975 GND GND.n230 0.0226354
R976 GND.n177 GND.n176 0.0213333
R977 GND.n145 GND 0.0200312
R978 GND.n81 GND 0.0200312
R979 GND.n92 GND 0.0200312
R980 GND.n93 GND 0.0200312
R981 GND.n108 GND 0.0200312
R982 GND.n132 GND 0.0174271
R983 GND.n144 GND 0.016776
R984 GND.n139 GND 0.016776
R985 GND.n169 GND 0.016125
R986 GND.n51 GND 0.016125
R987 GND.n61 GND 0.016125
R988 GND.n148 GND 0.016125
R989 GND.n176 GND.n31 0.0148229
R990 GND.n173 GND.n172 0.0148229
R991 GND.n168 GND.n46 0.0148229
R992 GND.n165 GND.n164 0.0148229
R993 GND.n161 GND.n51 0.0148229
R994 GND.n160 GND.n52 0.0148229
R995 GND.n157 GND.n156 0.0148229
R996 GND.n153 GND.n61 0.0148229
R997 GND.n152 GND.n62 0.0148229
R998 GND.n65 GND.n64 0.0148229
R999 GND.n153 GND 0.0122188
R1000 GND GND.n35 0.0115677
R1001 GND GND.n31 0.0115677
R1002 GND GND.n42 0.0115677
R1003 GND.n161 GND 0.0115677
R1004 GND GND.n91 0.0115677
R1005 GND GND.n107 0.0115677
R1006 GND GND.n117 0.0115677
R1007 GND.n126 GND 0.0115677
R1008 GND.n149 GND 0.0109167
R1009 GND.n145 GND.n144 0.0109167
R1010 GND.n82 GND.n81 0.0109167
R1011 GND.n83 GND.n80 0.0109167
R1012 GND.n91 GND.n90 0.0109167
R1013 GND.n93 GND.n92 0.0109167
R1014 GND.n99 GND.n98 0.0109167
R1015 GND.n74 GND.n73 0.0109167
R1016 GND.n104 GND.n103 0.0109167
R1017 GND.n107 GND.n71 0.0109167
R1018 GND.n108 GND 0.00570833
R1019 GND GND.n148 0.00440625
R1020 GND.n169 GND 0.00375521
R1021 GND.n98 GND 0.00180208
C0 x3.B x6.A1 0.13685f
C1 VDD x5.A0 0.90623f
C2 A0 a_3359_n2391# 0.10369f
C3 P0 x6.A0 0.21508f
C4 x5.A1 x5.A0 0.30332f
C5 a_4264_n1111# A6 0.10369f
C6 VDD a_5137_n2489# 0.10125f
C7 x5.A0 P1 0.14345f
C8 x5.A1 a_5137_n2489# 0.31847f
C9 x2.x4.A a_4263_n2391# 0.10668f
C10 a_5138_n1209# x1.x5.A1 0.2056f
C11 x1.x5.A0 a_5138_n1209# 0.10298f
C12 x5.A1 a_4903_n1962# 0.20119f
C13 a_5567_n1387# x1.x5.A1 0.10358f
C14 VDD x6.A0 1.30901f
C15 x6.A1 P2 0.35102f
C16 VDD x2.x4.A 0.34865f
C17 x6.A0 x5.A1 0.41866f
C18 x5.A1 x2.x4.A 0.21108f
C19 P1 a_4903_n1962# 0.10802f
C20 x5.A0 x4.A 0.38091f
C21 a_5958_n1111# x1.x4.A 0.22241f
C22 a_5566_n2667# x2.x5.A1 0.10358f
C23 x2.x5.A0 x2.x5.A1 0.37436f
C24 VDD a_3360_n1111# 0.15542f
C25 VDD a_3821_n1962# 0.23119f
C26 x2.x5.A1 x6.A1 0.3046f
C27 x1.x5.A0 x1.x4.A 0.2439f
C28 VDD a_3359_n2391# 0.15546f
C29 VDD a_5958_n1111# 0.14417f
C30 P0 a_4649_n1962# 0.14113f
C31 x6.A0 x4.A 0.13483f
C32 a_4075_n1962# x6.A1 0.20274f
C33 a_5957_n2391# x2.x4.A 0.22241f
C34 VDD x1.x5.A1 0.67981f
C35 VDD V 1.52394f
C36 a_5789_n1769# x3.B 0.10352f
C37 x1.x5.A0 VDD 0.47047f
C38 x2.x3.B x2.x4.A 0.34462f
C39 VDD a_4649_n1962# 0.14968f
C40 x5.A1 a_4649_n1962# 0.10791f
C41 a_5958_n1111# x4.A 0.11735f
C42 a_3360_n1111# x1.x3.B 0.10718f
C43 x2.x3.B a_3359_n2391# 0.10718f
C44 VDD a_5566_n2667# 0.16724f
C45 VDD x2.x5.A0 0.4792f
C46 VDD x6.A1 1.60918f
C47 x1.x3.B a_5958_n1111# 0.11187f
C48 x5.A1 a_5566_n2667# 0.24244f
C49 A3 A2 0.14021f
C50 x5.A1 x6.A1 1.44683f
C51 x1.x3.B x1.x5.A1 0.32143f
C52 P1 x6.A1 0.1446f
C53 x5.A0 a_4903_n1962# 0.11638f
C54 x6.A0 x5.A0 1.16452f
C55 A0 A1 0.14021f
C56 VDD A5 0.36836f
C57 a_4075_n1962# P2 0.37501f
C58 x5.A0 x1.x5.A1 0.13281f
C59 VDD x3.B 0.31019f
C60 VDD a_5789_n1769# 0.15462f
C61 VDD A1 0.37233f
C62 x5.A1 x3.B 0.43699f
C63 P0 P2 0.13442f
C64 A3 a_4263_n2391# 0.24818f
C65 A2 a_4263_n2391# 0.10369f
C66 A3 VDD 0.34974f
C67 x6.A0 x1.x5.A1 0.11767f
C68 x6.A0 V 0.10869f
C69 x1.x5.A0 x6.A0 0.15802f
C70 VDD P2 1.4137f
C71 x5.A1 P2 0.12921f
C72 x3.B x4.A 0.40142f
C73 A5 x1.x3.B 0.14383f
C74 a_5789_n1769# x4.A 0.19763f
C75 a_5957_n2391# x3.B 0.11455f
C76 VDD x2.x5.A1 0.73821f
C77 P1 P2 0.16252f
C78 a_5137_n2489# x2.x5.A0 0.10298f
C79 a_4075_n1962# P0 0.13169f
C80 x5.A1 x2.x5.A1 0.13271f
C81 a_5137_n2489# x6.A1 0.12168f
C82 x2.x3.B A1 0.14383f
C83 x2.x5.A0 x2.x4.A 0.2439f
C84 A7 x1.x4.A 0.14311f
C85 x6.A0 x6.A1 0.39757f
C86 VDD a_4075_n1962# 0.10243f
C87 VDD a_5567_n1387# 0.16337f
C88 x1.x5.A0 x1.x5.A1 0.37436f
C89 a_3821_n1962# x6.A1 0.10785f
C90 VDD A7 0.34173f
C91 a_3360_n1111# A4 0.10369f
C92 VDD x1.x4.A 0.34764f
C93 VDD P0 0.15502f
C94 x2.x3.B x2.x5.A1 0.32143f
C95 VDD a_4263_n2391# 0.16947f
C96 P0 P1 0.14682f
C97 V x6.A1 0.13677f
C98 VDD x5.A1 0.90558f
C99 x4.A x1.x4.A 0.18487f
C100 VDD P1 0.23055f
C101 A5 a_3360_n1111# 0.24818f
C102 x5.A1 P1 0.16301f
C103 A7 a_4264_n1111# 0.24818f
C104 a_4264_n1111# x1.x4.A 0.10668f
C105 x2.x4.A x3.B 0.17899f
C106 x1.x3.B x1.x4.A 0.34462f
C107 x2.x5.A0 x6.A1 0.15908f
C108 VDD x4.A 0.34701f
C109 VDD a_5957_n2391# 0.14436f
C110 x5.A1 x4.A 0.15563f
C111 A7 A6 0.14021f
C112 a_4903_n1962# P2 0.35718f
C113 VDD a_4264_n1111# 0.16563f
C114 A3 x2.x4.A 0.14311f
C115 x2.x3.B VDD 0.33494f
C116 x6.A0 P2 0.58568f
C117 a_3359_n2391# A1 0.24818f
C118 a_5137_n2489# x2.x5.A1 0.2056f
C119 VDD x1.x3.B 0.32766f
C120 x5.A0 a_5138_n1209# 0.31856f
C121 a_5567_n1387# x5.A0 0.24262f
C122 a_3821_n1962# P2 0.24185f
C123 P1 x1.x3.B 0.20237f
C124 a_5789_n1769# V 0.10601f
C125 x6.A0 a_5138_n1209# 0.12077f
C126 x5.A0 x1.x4.A 0.2325f
C127 x2.x3.B a_5957_n2391# 0.11187f
C128 a_4075_n1962# x6.A0 0.10464f
C129 V P2 1.21592f
C130 A5 A4 0.14021f
C131 a_4649_n1962# P2 0.24821f
C132 A2 GND 0.33393f
C133 A0 GND 0.34762f
C134 A3 GND 0.42042f
C135 A1 GND 0.43047f
C136 V GND 1.59045f
C137 P1 GND 1.55608f
C138 P0 GND 1.14126f
C139 P2 GND 1.66606f
C140 A6 GND 0.33625f
C141 A4 GND 0.34821f
C142 A7 GND 0.4277f
C143 A5 GND 0.43448f
C144 VDD GND 15.39807f
C145 a_5566_n2667# GND 0.26934f
C146 x2.x5.A0 GND 0.28537f
C147 x2.x5.A1 GND 0.34258f
C148 x2.x3.B GND 1.23131f
C149 x2.x4.A GND 1.3878f
C150 a_5957_n2391# GND 0.20845f
C151 a_5137_n2489# GND 0.23231f
C152 a_4263_n2391# GND 0.20071f
C153 a_3359_n2391# GND 0.22278f
C154 x3.B GND 0.72628f
C155 a_5789_n1769# GND 0.21878f
C156 a_4903_n1962# GND 0.22709f
C157 x5.A1 GND 0.94343f
C158 a_4649_n1962# GND 0.2549f
C159 a_4075_n1962# GND 0.22175f
C160 x6.A1 GND 0.51824f
C161 a_3821_n1962# GND 0.29556f
C162 x4.A GND 0.97797f
C163 a_5567_n1387# GND 0.27276f
C164 x5.A0 GND 1.57096f
C165 x6.A0 GND 0.72366f
C166 x1.x5.A0 GND 0.29433f
C167 x1.x5.A1 GND 0.58725f
C168 x1.x3.B GND 1.04777f
C169 x1.x4.A GND 1.37071f
C170 a_5958_n1111# GND 0.20904f
C171 a_5138_n1209# GND 0.23679f
C172 a_4264_n1111# GND 0.20474f
C173 a_3360_n1111# GND 0.22355f
C174 VDD.t20 GND 0.24625f
C175 VDD.t24 GND 0.19509f
C176 VDD.t22 GND 0.11942f
C177 VDD.t13 GND 0.18497f
C178 VDD.t49 GND 0.20467f
C179 VDD.t63 GND 0.14009f
C180 VDD.t8 GND 0.23422f
C181 VDD.t36 GND 0.2572f
C182 VDD.t51 GND 0.10397f
C183 VDD.t71 GND 0.1193f
C184 VDD.t43 GND 0.17293f
C185 VDD.n47 GND 0.25035f
C186 VDD.t48 GND 0.17621f
C187 VDD.t53 GND 0.10726f
C188 VDD.t87 GND 0.10507f
C189 VDD.t77 GND 0.11602f
C190 VDD.t17 GND 0.21671f
C191 VDD.t85 GND 0.10397f
C192 VDD.t84 GND 0.11273f
C193 VDD.t45 GND 0.11602f
C194 VDD.n48 GND 0.19562f
C195 VDD.t4 GND 0.18387f
C196 VDD.t73 GND 0.11164f
C197 VDD.t82 GND 0.12258f
C198 VDD.t57 GND 0.12971f
C199 VDD.n54 GND 0.23142f
C200 VDD.t34 GND 0.14966f
C201 VDD.t68 GND 0.1555f
C202 VDD.n61 GND 0.19551f
C203 VDD.t30 GND 0.24625f
C204 VDD.t32 GND 0.14966f
C205 VDD.t39 GND 0.14064f
C206 VDD.t55 GND 0.15178f
C207 VDD.t44 GND 0.16823f
C208 VDD.t41 GND 0.11251f
C209 VDD.t37 GND 0.14966f
C210 VDD.t59 GND 0.1555f
C211 VDD.n67 GND 0.19922f
C212 A5.n0 GND 0.13766f
C213 A5.n3 GND 0.34293f
C214 A7.n0 GND 0.14773f
C215 A7.n3 GND 0.36802f
C216 A4.n0 GND 0.10221f
C217 A6.n0 GND 0.12461f
C218 P2.n0 GND 0.40653f
C219 P2.n1 GND 0.16455f
C220 P2.t1 GND 0.17862f
C221 P2.t0 GND 0.23409f
C222 P2.n4 GND 0.26091f
C223 P2.n5 GND 0.16455f
C224 P2.n7 GND 0.37118f
C225 P2.n8 GND 0.46473f
C226 P2.n9 GND 0.45825f
C227 P2.n10 GND 0.87621f
C228 P0.n0 GND 0.13494f
C229 P0.n2 GND 0.11461f
C230 P0.n3 GND 0.10017f
C231 P1.n0 GND 0.26647f
C232 P1.n2 GND 0.11417f
C233 V.t1 GND 0.28896f
C234 V.n0 GND 0.66667f
C235 V.t0 GND 0.33483f
C236 V.n1 GND 0.63363f
C237 A1.n0 GND 0.13783f
C238 A1.n3 GND 0.34335f
C239 A3.n0 GND 0.14865f
C240 A3.n3 GND 0.3703f
C241 A0.n0 GND 0.102f
C242 A2.n0 GND 0.12496f
.ends
