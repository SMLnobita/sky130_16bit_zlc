* NGSPICE file created from zlc4.ext - technology: sky130A

.subckt zlc4 A1 A0 A3 A2 P0 P1 V VDD GND
X0 VDD.t1 a_1238_n1757# P0.t0 VDD.t0 sky130_fd_pr__pfet_01v8_hvt ad=0.15835 pd=1.395 as=0.26 ps=2.52 w=1 l=0.15
X1 a_1380_n1582# P1.t5 VDD.t21 VDD.t20 sky130_fd_pr__pfet_01v8_hvt ad=0.07665 pd=0.785 as=0.15835 ps=1.395 w=0.42 l=0.15
X2 a_1238_n1757# x5.A0 a_1380_n1582# VDD.t14 sky130_fd_pr__pfet_01v8_hvt ad=0.1932 pd=1.34 as=0.07665 ps=0.785 w=0.42 l=0.15
X3 x5.A1 A1.t0 GND.t33 GND.t32 sky130_fd_pr__nfet_01v8 ad=0.169 pd=1.82 as=0.169 ps=1.82 w=0.65 l=0.15
X4 P1.t1 x4.A GND.t11 GND.t10 sky130_fd_pr__nfet_01v8 ad=0.169 pd=1.82 as=0.169 ps=1.82 w=0.65 l=0.15
X5 a_n540_n1659# A0.t0 GND.t29 GND.t28 sky130_fd_pr__nfet_01v8 ad=0.0567 pd=0.69 as=0.1092 ps=1.36 w=0.42 l=0.15
X6 x5.A0 A3.t0 GND.t19 GND.t18 sky130_fd_pr__nfet_01v8 ad=0.169 pd=1.82 as=0.169 ps=1.82 w=0.65 l=0.15
X7 a_2140_n1659# x3.B a_2058_n1659# VDD.t25 sky130_fd_pr__pfet_01v8_hvt ad=0.0441 pd=0.63 as=0.1092 ps=1.36 w=0.42 l=0.15
X8 a_1238_n1757# x5.A1 a_1380_n1909# GND.t15 sky130_fd_pr__nfet_01v8 ad=0.09975 pd=0.895 as=0.0693 ps=0.75 w=0.42 l=0.15
X9 GND.t13 a_1667_n1935# a_1601_n1909# GND.t12 sky130_fd_pr__nfet_01v8 ad=0.1449 pd=1.11 as=0.0693 ps=0.75 w=0.42 l=0.15
X10 a_n458_n1659# A0.t1 a_n540_n1659# VDD.t26 sky130_fd_pr__pfet_01v8_hvt ad=0.0441 pd=0.63 as=0.1092 ps=1.36 w=0.42 l=0.15
X11 a_446_n1659# A2.t1 a_364_n1659# VDD.t24 sky130_fd_pr__pfet_01v8_hvt ad=0.0441 pd=0.63 as=0.1092 ps=1.36 w=0.42 l=0.15
X12 GND.t31 A1.t1 a_n540_n1659# GND.t30 sky130_fd_pr__nfet_01v8 ad=0.10025 pd=0.985 as=0.0567 ps=0.69 w=0.42 l=0.15
X13 x5.A1 A1.t2 VDD.t28 VDD.t27 sky130_fd_pr__pfet_01v8_hvt ad=0.26 pd=2.52 as=0.26 ps=2.52 w=1 l=0.15
X14 a_1667_n1935# P1.t2 GND.t21 GND.t20 sky130_fd_pr__nfet_01v8 ad=0.1092 pd=1.36 as=0.1449 ps=1.11 w=0.42 l=0.15
X15 P1.t0 x4.A VDD.t11 VDD.t10 sky130_fd_pr__pfet_01v8_hvt ad=0.26 pd=2.52 as=0.26 ps=2.52 w=1 l=0.15
X16 x5.A0 A3.t2 VDD.t17 VDD.t16 sky130_fd_pr__pfet_01v8_hvt ad=0.26 pd=2.52 as=0.26 ps=2.52 w=1 l=0.15
X17 a_1697_n1582# x5.A1 a_1238_n1757# VDD.t15 sky130_fd_pr__pfet_01v8_hvt ad=0.0441 pd=0.63 as=0.1932 ps=1.34 w=0.42 l=0.15
X18 x3.B a_n540_n1659# GND.t7 GND.t6 sky130_fd_pr__nfet_01v8 ad=0.169 pd=1.82 as=0.10025 ps=0.985 w=0.65 l=0.15
X19 VDD.t13 a_1667_n1935# a_1697_n1582# VDD.t12 sky130_fd_pr__pfet_01v8_hvt ad=0.0693 pd=0.75 as=0.0441 ps=0.63 w=0.42 l=0.15
X20 x4.A a_364_n1659# GND.t5 GND.t4 sky130_fd_pr__nfet_01v8 ad=0.169 pd=1.82 as=0.10025 ps=0.985 w=0.65 l=0.15
X21 VDD.t30 A1.t3 a_n458_n1659# VDD.t29 sky130_fd_pr__pfet_01v8_hvt ad=0.14575 pd=1.335 as=0.0441 ps=0.63 w=0.42 l=0.15
X22 a_1667_n1935# P1.t4 VDD.t23 VDD.t22 sky130_fd_pr__pfet_01v8_hvt ad=0.1176 pd=1.4 as=0.0693 ps=0.75 w=0.42 l=0.15
X23 GND.t9 x4.A a_2058_n1659# GND.t8 sky130_fd_pr__nfet_01v8 ad=0.10025 pd=0.985 as=0.0567 ps=0.69 w=0.42 l=0.15
X24 GND.t17 A3.t1 a_364_n1659# GND.t16 sky130_fd_pr__nfet_01v8 ad=0.10025 pd=0.985 as=0.0567 ps=0.69 w=0.42 l=0.15
X25 a_2058_n1659# x3.B GND.t27 GND.t26 sky130_fd_pr__nfet_01v8 ad=0.0567 pd=0.69 as=0.1092 ps=1.36 w=0.42 l=0.15
X26 V.t1 a_2058_n1659# GND.t3 GND.t2 sky130_fd_pr__nfet_01v8 ad=0.169 pd=1.82 as=0.10025 ps=0.985 w=0.65 l=0.15
X27 x3.B a_n540_n1659# VDD.t7 VDD.t6 sky130_fd_pr__pfet_01v8_hvt ad=0.34 pd=2.68 as=0.14575 ps=1.335 w=1 l=0.15
X28 x4.A a_364_n1659# VDD.t5 VDD.t4 sky130_fd_pr__pfet_01v8_hvt ad=0.34 pd=2.68 as=0.14575 ps=1.335 w=1 l=0.15
X29 a_1380_n1909# P1.t3 GND.t23 GND.t22 sky130_fd_pr__nfet_01v8 ad=0.0693 pd=0.75 as=0.11285 ps=1.045 w=0.42 l=0.15
X30 a_364_n1659# A2.t0 GND.t25 GND.t24 sky130_fd_pr__nfet_01v8 ad=0.0567 pd=0.69 as=0.1092 ps=1.36 w=0.42 l=0.15
X31 GND.t1 a_1238_n1757# P0.t1 GND.t0 sky130_fd_pr__nfet_01v8 ad=0.11285 pd=1.045 as=0.169 ps=1.82 w=0.65 l=0.15
X32 a_1601_n1909# x5.A0 a_1238_n1757# GND.t14 sky130_fd_pr__nfet_01v8 ad=0.0693 pd=0.75 as=0.09975 ps=0.895 w=0.42 l=0.15
X33 VDD.t9 x4.A a_2140_n1659# VDD.t8 sky130_fd_pr__pfet_01v8_hvt ad=0.14575 pd=1.335 as=0.0441 ps=0.63 w=0.42 l=0.15
X34 VDD.t19 A3.t3 a_446_n1659# VDD.t18 sky130_fd_pr__pfet_01v8_hvt ad=0.14575 pd=1.335 as=0.0441 ps=0.63 w=0.42 l=0.15
X35 V.t0 a_2058_n1659# VDD.t3 VDD.t2 sky130_fd_pr__pfet_01v8_hvt ad=0.34 pd=2.68 as=0.14575 ps=1.335 w=1 l=0.15
R0 V.n0 V.t0 340.584
R1 V.n1 V.t1 149.881
R2 V V.n1 24.5846
R3 V.n1 V 15.2246
R4 V V.n0 2.4386
R5 V.n0 V 1.43601
R6 P1 P1.n5 428.005
R7 P1.n3 P1.t2 329.902
R8 P1.n5 P1.t5 272.062
R9 P1.n1 P1.t0 232.845
R10 P1.n5 P1.t3 206.19
R11 P1 P1.t1 152.889
R12 P1.n4 P1.n3 152
R13 P1.n3 P1.t4 148.35
R14 P1.n0 P1 93.8672
R15 P1.n4 P1.n2 16.5434
R16 P1.n2 P1.n1 9.3005
R17 P1.n0 P1 5.65847
R18 P1.n1 P1.n0 2.71565
R19 P1.n0 P1 1.55202
R20 P1 P1.n4 0.674184
R21 P1.n2 P1 0.3755
R22 P0.n3 P0 593.216
R23 P0.n3 P0.n0 585
R24 P0.n4 P0.n3 585
R25 P0.n1 P0.t1 209.923
R26 P0.n4 P0.n1 74.3207
R27 P0.n3 P0.t0 26.5955
R28 P0.n2 P0 15.9929
R29 P0 P0.n0 8.21543
R30 P0 P0.n4 4.77662
R31 P0.n2 P0.n0 4.58557
R32 P0.n1 P0 2.5103
R33 P0 P0.n2 0.191545
R34 A2.n0 A2.t0 192.639
R35 A2.n1 A2.n0 152
R36 A2.n0 A2.t1 134.799
R37 A2.n1 A2 9.78757
R38 A2 A2.n1 6.17193
R39 A0.n0 A0.t0 192.639
R40 A0.n1 A0.n0 152
R41 A0.n0 A0.t1 134.799
R42 A0.n1 A0 9.78757
R43 A0 A0.n1 6.17193
R44 A3.n0 A3.t2 230.576
R45 A3.n1 A3.t1 206.19
R46 A3.n0 A3.t0 158.275
R47 A3.n4 A3.n0 152.268
R48 A3.n2 A3.n1 152
R49 A3.n1 A3.t3 148.35
R50 A3.n4 A3.n3 11.0554
R51 A3.n3 A3.n2 10.8751
R52 A3 A3.n4 6.4005
R53 A3.n3 A3 1.19693
R54 A3.n2 A3 0.686214
R55 A1.n0 A1.t2 230.576
R56 A1.n1 A1.t1 206.19
R57 A1.n0 A1.t0 158.275
R58 A1.n4 A1.n0 152.268
R59 A1.n2 A1.n1 152
R60 A1.n1 A1.t3 148.35
R61 A1.n4 A1.n3 11.0554
R62 A1.n3 A1.n2 10.8751
R63 A1 A1.n4 6.4005
R64 A1.n3 A1 1.19693
R65 A1.n2 A1 0.686214
R66 VDD.t14 VDD.t15 633.333
R67 VDD.n5 VDD.n4 629.801
R68 VDD.n67 VDD.t16 553.428
R69 VDD.n66 VDD.t27 553.428
R70 VDD.t2 VDD 547.509
R71 VDD VDD.t4 547.509
R72 VDD VDD.t6 547.509
R73 VDD.t22 VDD 500.156
R74 VDD.n67 VDD 467.601
R75 VDD VDD.n66 446.885
R76 VDD.t0 VDD.t20 322.587
R77 VDD.n39 VDD.n38 315.303
R78 VDD.n17 VDD.n9 315.303
R79 VDD.n54 VDD.n53 315.301
R80 VDD VDD.t10 313.707
R81 VDD VDD.t25 313.707
R82 VDD.t16 VDD 313.707
R83 VDD.t24 VDD 313.707
R84 VDD.t27 VDD 313.707
R85 VDD.t26 VDD 313.707
R86 VDD.t20 VDD.t14 304.829
R87 VDD.t8 VDD.t2 287.072
R88 VDD.t4 VDD.t18 287.072
R89 VDD.t6 VDD.t29 287.072
R90 VDD.t12 VDD.t22 284.113
R91 VDD.n60 VDD.t28 255.905
R92 VDD.n41 VDD.t17 255.905
R93 VDD.n11 VDD.t11 255.905
R94 VDD.n34 VDD.n1 235.248
R95 VDD.n66 VDD.n65 213.119
R96 VDD.n68 VDD.n67 213.119
R97 VDD.t25 VDD.t8 213.084
R98 VDD.t15 VDD.t12 213.084
R99 VDD.t18 VDD.t24 213.084
R100 VDD.t29 VDD.t26 213.084
R101 VDD.n1 VDD.t21 123.507
R102 VDD.n53 VDD.t30 96.1553
R103 VDD.n38 VDD.t19 96.1553
R104 VDD.n9 VDD.t9 96.1553
R105 VDD.n4 VDD.t13 86.7743
R106 VDD.n4 VDD.t23 68.0124
R107 VDD VDD.t0 59.1905
R108 VDD.n35 VDD.n34 43.1829
R109 VDD.n59 VDD.n58 34.6358
R110 VDD.n58 VDD.n52 34.6358
R111 VDD.n61 VDD.n37 34.6358
R112 VDD.n47 VDD.n46 34.6358
R113 VDD.n48 VDD.n47 34.6358
R114 VDD.n43 VDD.n36 34.6358
R115 VDD.n21 VDD.n7 34.6358
R116 VDD.n22 VDD.n21 34.6358
R117 VDD.n23 VDD.n22 34.6358
R118 VDD.n27 VDD.n26 34.6358
R119 VDD.n28 VDD.n27 34.6358
R120 VDD.n28 VDD.n2 34.6358
R121 VDD.n32 VDD.n2 34.6358
R122 VDD.n33 VDD.n32 34.6358
R123 VDD.n15 VDD.n10 34.6358
R124 VDD.n16 VDD.n15 34.6358
R125 VDD.n17 VDD.n7 34.2593
R126 VDD.n1 VDD.t1 28.752
R127 VDD.n53 VDD.t7 25.6105
R128 VDD.n38 VDD.t5 25.6105
R129 VDD.n9 VDD.t3 25.6105
R130 VDD.n65 VDD.n37 23.7181
R131 VDD.n68 VDD.n36 23.7181
R132 VDD.n12 VDD.n11 18.2003
R133 VDD.n23 VDD.n5 17.3181
R134 VDD.n26 VDD.n5 17.3181
R135 VDD.n61 VDD.n60 10.5417
R136 VDD.n43 VDD.n41 10.5417
R137 VDD.n54 VDD.n52 10.1652
R138 VDD.n48 VDD.n39 10.1652
R139 VDD.n17 VDD.n16 10.1652
R140 VDD.n13 VDD.n10 9.3005
R141 VDD.n15 VDD.n14 9.3005
R142 VDD.n16 VDD.n8 9.3005
R143 VDD.n18 VDD.n17 9.3005
R144 VDD.n19 VDD.n7 9.3005
R145 VDD.n21 VDD.n20 9.3005
R146 VDD.n22 VDD.n6 9.3005
R147 VDD.n24 VDD.n23 9.3005
R148 VDD.n26 VDD.n25 9.3005
R149 VDD.n27 VDD.n3 9.3005
R150 VDD.n29 VDD.n28 9.3005
R151 VDD.n30 VDD.n2 9.3005
R152 VDD.n32 VDD.n31 9.3005
R153 VDD.n33 VDD.n0 9.3005
R154 VDD.n69 VDD.n68 9.3005
R155 VDD.n42 VDD.n36 9.3005
R156 VDD.n44 VDD.n43 9.3005
R157 VDD.n46 VDD.n45 9.3005
R158 VDD.n47 VDD.n40 9.3005
R159 VDD.n49 VDD.n48 9.3005
R160 VDD.n65 VDD.n64 9.3005
R161 VDD.n63 VDD.n37 9.3005
R162 VDD.n62 VDD.n61 9.3005
R163 VDD.n59 VDD.n51 9.3005
R164 VDD.n58 VDD.n57 9.3005
R165 VDD.n56 VDD.n52 9.3005
R166 VDD.n60 VDD.n59 8.28285
R167 VDD.n46 VDD.n41 8.28285
R168 VDD.n11 VDD.n10 8.28285
R169 VDD.n50 VDD.n39 7.5914
R170 VDD.n55 VDD.n54 7.5914
R171 VDD.n34 VDD.n33 0.753441
R172 VDD VDD.n50 0.237498
R173 VDD.n55 VDD 0.237498
R174 VDD.n12 VDD 0.159538
R175 VDD.n50 VDD.n49 0.146355
R176 VDD.n56 VDD.n55 0.146355
R177 VDD.n13 VDD.n12 0.141672
R178 VDD.n14 VDD.n8 0.120292
R179 VDD.n18 VDD.n8 0.120292
R180 VDD.n19 VDD.n18 0.120292
R181 VDD.n20 VDD.n19 0.120292
R182 VDD.n24 VDD.n6 0.120292
R183 VDD.n25 VDD.n24 0.120292
R184 VDD.n25 VDD.n3 0.120292
R185 VDD.n29 VDD.n3 0.120292
R186 VDD.n30 VDD.n29 0.120292
R187 VDD.n31 VDD.n30 0.120292
R188 VDD.n31 VDD.n0 0.120292
R189 VDD.n35 VDD.n0 0.120292
R190 VDD.n44 VDD.n42 0.120292
R191 VDD.n45 VDD.n44 0.120292
R192 VDD.n49 VDD.n40 0.120292
R193 VDD.n63 VDD.n62 0.120292
R194 VDD.n62 VDD.n51 0.120292
R195 VDD.n57 VDD.n56 0.120292
R196 VDD.n14 VDD 0.0981562
R197 VDD VDD.n6 0.0603958
R198 VDD VDD.n69 0.0603958
R199 VDD.n42 VDD 0.0603958
R200 VDD VDD.n40 0.0603958
R201 VDD.n64 VDD 0.0603958
R202 VDD VDD.n63 0.0603958
R203 VDD.n57 VDD 0.0603958
R204 VDD.n69 VDD 0.03175
R205 VDD.n64 VDD 0.03175
R206 VDD VDD.n13 0.0226354
R207 VDD.n20 VDD 0.0226354
R208 VDD.n45 VDD 0.0226354
R209 VDD VDD.n51 0.0226354
R210 VDD VDD.n35 0.0213333
R211 GND.t18 GND.n38 2662.78
R212 GND.n64 GND.t32 2662.78
R213 GND.t2 GND 2634.3
R214 GND.t4 GND 2634.3
R215 GND GND.t6 2634.3
R216 GND.t20 GND 2406.47
R217 GND.t12 GND.t20 2392.23
R218 GND.n38 GND 2392.23
R219 GND.n64 GND 2150.16
R220 GND.t15 GND.t14 1779.94
R221 GND.t0 GND.t22 1552.1
R222 GND GND.t10 1509.39
R223 GND GND.t18 1509.39
R224 GND.t32 GND 1509.39
R225 GND.t8 GND.t2 1381.23
R226 GND.t16 GND.t4 1381.23
R227 GND.t6 GND.t30 1381.23
R228 GND.t14 GND.t12 1366.99
R229 GND.t22 GND.t15 1366.99
R230 GND GND.t26 1338.51
R231 GND GND.t24 1338.51
R232 GND.t28 GND 1338.51
R233 GND.n65 GND.n64 1198.25
R234 GND.n80 GND.n38 1198.25
R235 GND.t26 GND.t8 1196.12
R236 GND.t24 GND.t16 1196.12
R237 GND.t30 GND.t28 1196.12
R238 GND.n52 GND.t29 246.506
R239 GND.n68 GND.t25 246.506
R240 GND.n19 GND.t27 246.506
R241 GND.n50 GND.n49 210.601
R242 GND.n44 GND.n43 210.601
R243 GND.n7 GND.n6 210.601
R244 GND.n36 GND.n35 199.739
R245 GND.n28 GND.n27 185
R246 GND.n26 GND.n25 185
R247 GND.n46 GND.t33 158.361
R248 GND.n40 GND.t19 158.361
R249 GND.n9 GND.t11 158.361
R250 GND GND.t0 142.395
R251 GND.n27 GND.n26 97.1434
R252 GND.n35 GND.t23 74.2862
R253 GND.n27 GND.t13 61.4291
R254 GND.n49 GND.t31 55.7148
R255 GND.n43 GND.t17 55.7148
R256 GND.n6 GND.t9 55.7148
R257 GND.n26 GND.t21 38.5719
R258 GND.n63 GND.n45 34.6358
R259 GND.n59 GND.n58 34.6358
R260 GND.n58 GND.n47 34.6358
R261 GND.n54 GND.n53 34.6358
R262 GND.n79 GND.n39 34.6358
R263 GND.n75 GND.n74 34.6358
R264 GND.n74 GND.n41 34.6358
R265 GND.n70 GND.n69 34.6358
R266 GND.n13 GND.n12 34.6358
R267 GND.n14 GND.n13 34.6358
R268 GND.n18 GND.n17 34.6358
R269 GND.n20 GND.n4 34.6358
R270 GND.n24 GND.n4 34.6358
R271 GND.n29 GND.n1 34.6358
R272 GND.n33 GND.n1 34.6358
R273 GND.n34 GND.n33 34.6358
R274 GND.n49 GND.t7 26.8576
R275 GND.n43 GND.t5 26.8576
R276 GND.n6 GND.t3 26.8576
R277 GND.n35 GND.t1 25.4291
R278 GND.n65 GND.n63 23.7181
R279 GND.n80 GND.n79 23.7181
R280 GND.n36 GND.n34 22.9652
R281 GND.n29 GND.n28 22.2496
R282 GND.n10 GND.n9 18.2003
R283 GND.n50 GND.n47 16.1887
R284 GND.n44 GND.n41 16.1887
R285 GND.n14 GND.n7 16.1887
R286 GND.n53 GND.n52 15.0593
R287 GND.n69 GND.n68 15.0593
R288 GND.n19 GND.n18 15.0593
R289 GND.n25 GND.n24 11.7085
R290 GND.n52 GND.n51 10.8064
R291 GND.n68 GND.n67 10.8064
R292 GND.n46 GND.n45 10.5417
R293 GND.n40 GND.n39 10.5417
R294 GND.n34 GND.n0 9.3005
R295 GND.n33 GND.n32 9.3005
R296 GND.n31 GND.n1 9.3005
R297 GND.n30 GND.n29 9.3005
R298 GND.n3 GND.n2 9.3005
R299 GND.n24 GND.n23 9.3005
R300 GND.n22 GND.n4 9.3005
R301 GND.n21 GND.n20 9.3005
R302 GND.n18 GND.n5 9.3005
R303 GND.n17 GND.n16 9.3005
R304 GND.n15 GND.n14 9.3005
R305 GND.n13 GND.n8 9.3005
R306 GND.n12 GND.n11 9.3005
R307 GND.n69 GND.n42 9.3005
R308 GND.n71 GND.n70 9.3005
R309 GND.n72 GND.n41 9.3005
R310 GND.n74 GND.n73 9.3005
R311 GND.n76 GND.n75 9.3005
R312 GND.n81 GND.n80 9.3005
R313 GND.n79 GND.n78 9.3005
R314 GND.n77 GND.n39 9.3005
R315 GND.n53 GND.n48 9.3005
R316 GND.n55 GND.n54 9.3005
R317 GND.n56 GND.n47 9.3005
R318 GND.n58 GND.n57 9.3005
R319 GND.n60 GND.n59 9.3005
R320 GND.n66 GND.n65 9.3005
R321 GND.n63 GND.n62 9.3005
R322 GND.n61 GND.n45 9.3005
R323 GND.n37 GND.n36 7.12063
R324 GND.n59 GND.n46 6.77697
R325 GND.n75 GND.n40 6.77697
R326 GND.n12 GND.n9 6.77697
R327 GND.n25 GND.n3 4.35795
R328 GND.n54 GND.n50 2.25932
R329 GND.n70 GND.n44 2.25932
R330 GND.n17 GND.n7 2.25932
R331 GND.n28 GND.n3 1.8161
R332 GND.n20 GND.n19 1.50638
R333 GND.n10 GND 0.159538
R334 GND.n37 GND.n0 0.148519
R335 GND.n11 GND.n10 0.141672
R336 GND.n15 GND.n8 0.120292
R337 GND.n16 GND.n15 0.120292
R338 GND.n16 GND.n5 0.120292
R339 GND.n21 GND.n5 0.120292
R340 GND.n23 GND.n22 0.120292
R341 GND.n23 GND.n2 0.120292
R342 GND.n30 GND.n2 0.120292
R343 GND.n31 GND.n30 0.120292
R344 GND.n32 GND.n31 0.120292
R345 GND.n32 GND.n0 0.120292
R346 GND.n78 GND.n77 0.120292
R347 GND.n77 GND.n76 0.120292
R348 GND.n73 GND.n72 0.120292
R349 GND.n72 GND.n71 0.120292
R350 GND.n71 GND.n42 0.120292
R351 GND.n67 GND.n42 0.120292
R352 GND.n62 GND.n61 0.120292
R353 GND.n61 GND.n60 0.120292
R354 GND.n57 GND.n56 0.120292
R355 GND.n56 GND.n55 0.120292
R356 GND.n55 GND.n48 0.120292
R357 GND.n51 GND.n48 0.120292
R358 GND GND.n37 0.11354
R359 GND GND.n8 0.0981562
R360 GND.n22 GND 0.0603958
R361 GND GND.n81 0.0603958
R362 GND.n78 GND 0.0603958
R363 GND.n73 GND 0.0603958
R364 GND GND.n66 0.0603958
R365 GND.n62 GND 0.0603958
R366 GND.n57 GND 0.0603958
R367 GND.n81 GND 0.0330521
R368 GND.n66 GND 0.0330521
R369 GND.n11 GND 0.0226354
R370 GND GND.n21 0.0226354
R371 GND.n76 GND 0.0226354
R372 GND.n67 GND 0.0226354
R373 GND.n60 GND 0.0226354
R374 GND.n51 GND 0.0226354
C0 VDD P1 0.77223f
C1 VDD a_364_n1659# 0.16095f
C2 x3.B x4.A 0.34462f
C3 x5.A1 P1 0.13242f
C4 A3 VDD 0.33558f
C5 a_n540_n1659# x3.B 0.10718f
C6 x5.A0 x4.A 0.2439f
C7 a_1667_n1935# P1 0.24236f
C8 VDD x5.A1 0.66453f
C9 VDD a_2058_n1659# 0.14381f
C10 x5.A0 a_1238_n1757# 0.10298f
C11 VDD a_1667_n1935# 0.16201f
C12 x5.A1 a_1667_n1935# 0.10358f
C13 P0 P1 0.55337f
C14 VDD P0 0.94609f
C15 x4.A P1 0.20981f
C16 x5.A1 P0 0.11737f
C17 x4.A a_364_n1659# 0.10668f
C18 A3 x4.A 0.14311f
C19 A1 VDD 0.33605f
C20 V P1 0.10369f
C21 A2 a_364_n1659# 0.10369f
C22 VDD x4.A 0.3425f
C23 A3 A2 0.14021f
C24 a_n540_n1659# VDD 0.14624f
C25 VDD V 0.1996f
C26 P1 a_1238_n1757# 0.31835f
C27 a_2058_n1659# x4.A 0.22241f
C28 V a_2058_n1659# 0.11269f
C29 VDD x3.B 0.29377f
C30 x5.A1 x3.B 0.32143f
C31 x5.A1 a_1238_n1757# 0.2056f
C32 x5.A0 VDD 0.46669f
C33 x5.A0 x5.A1 0.37436f
C34 x3.B a_2058_n1659# 0.11187f
C35 a_n540_n1659# A1 0.24818f
C36 A1 A0 0.14021f
C37 V x4.A 0.17609f
C38 P0 a_1238_n1757# 0.12062f
C39 a_n540_n1659# A0 0.10369f
C40 x5.A0 P0 0.15799f
C41 A3 a_364_n1659# 0.24818f
C42 A1 x3.B 0.14383f
C43 V GND 0.45284f
C44 P1 GND 1.15895f
C45 P0 GND 1.15967f
C46 A2 GND 0.33612f
C47 A0 GND 0.34702f
C48 A3 GND 0.42862f
C49 A1 GND 0.43409f
C50 VDD GND 5.82942f
C51 a_1667_n1935# GND 0.2678f
C52 x5.A0 GND 0.29221f
C53 x5.A1 GND 0.58552f
C54 x3.B GND 1.26431f
C55 x4.A GND 1.35811f
C56 a_2058_n1659# GND 0.19535f
C57 a_1238_n1757# GND 0.23414f
C58 a_364_n1659# GND 0.20707f
C59 a_n540_n1659# GND 0.22433f
C60 VDD.t10 GND 0.22375f
C61 VDD.t2 GND 0.13598f
C62 VDD.t22 GND 0.12779f
C63 VDD.t15 GND 0.13791f
C64 VDD.t14 GND 0.15286f
C65 VDD.t20 GND 0.10223f
C66 VDD.t6 GND 0.13598f
C67 VDD.t27 GND 0.14129f
C68 VDD.n66 GND 0.17764f
C69 VDD.t4 GND 0.13598f
C70 VDD.t16 GND 0.14129f
C71 VDD.n67 GND 0.18102f
C72 A1.n0 GND 0.13203f
C73 A1.n3 GND 0.32891f
C74 A3.n0 GND 0.146f
C75 A3.n3 GND 0.3637f
C76 A0.n0 GND 0.10005f
C77 A2.n0 GND 0.12154f
C78 P0.t1 GND 0.14658f
C79 P0.n1 GND 0.1432f
C80 P0.n2 GND 0.2521f
C81 P0.n3 GND 0.18408f
C82 P0.n4 GND 0.1426f
C83 P1.t0 GND 0.19017f
C84 P1.t1 GND 0.12569f
C85 P1.n1 GND 0.24049f
C86 P1.n2 GND 0.5126f
C87 P1.n3 GND 0.12712f
C88 P1.n5 GND 0.30442f
C89 V.t0 GND 0.10424f
C90 V.n0 GND 0.12565f
C91 V.n1 GND 0.19831f
.ends
