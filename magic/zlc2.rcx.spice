* NGSPICE file created from zlc2.ext - technology: sky130A

.subckt zlc2 HI LO P V VDD GND
X0 VDD.t3 HI.t3 a_n206_n743# VDD.t2 sky130_fd_pr__pfet_01v8_hvt ad=0.14575 pd=1.335 as=0.0441 ps=0.63 w=0.42 l=0.15
X1 a_n206_n743# LO.t1 a_n288_n743# VDD.t6 sky130_fd_pr__pfet_01v8_hvt ad=0.0441 pd=0.63 as=0.1092 ps=1.36 w=0.42 l=0.15
X2 V.t0 a_n288_n743# VDD.t1 VDD.t0 sky130_fd_pr__pfet_01v8_hvt ad=0.34 pd=2.68 as=0.14575 ps=1.335 w=1 l=0.15
X3 V.t1 a_n288_n743# GND.t1 GND.t0 sky130_fd_pr__nfet_01v8 ad=0.169 pd=1.82 as=0.10025 ps=0.985 w=0.65 l=0.15
X4 a_n288_n743# LO.t0 GND.t7 GND.t6 sky130_fd_pr__nfet_01v8 ad=0.0567 pd=0.69 as=0.1092 ps=1.36 w=0.42 l=0.15
X5 P.t1 HI.t2 VDD.t5 VDD.t4 sky130_fd_pr__pfet_01v8_hvt ad=0.26 pd=2.52 as=0.26 ps=2.52 w=1 l=0.15
X6 P.t0 HI.t0 GND.t5 GND.t4 sky130_fd_pr__nfet_01v8 ad=0.169 pd=1.82 as=0.169 ps=1.82 w=0.65 l=0.15
X7 GND.t3 HI.t1 a_n288_n743# GND.t2 sky130_fd_pr__nfet_01v8 ad=0.10025 pd=0.985 as=0.0567 ps=0.69 w=0.42 l=0.15
R0 P.n0 P.t1 221.157
R1 P P.t0 152.889
R2 P.n1 P.n0 14.4037
R3 P.n0 P 13.9617
R4 P.n1 P 2.22659
R5 P P.n1 1.55202
R6 V.n0 V.t0 340.584
R7 V.n1 V.t1 132.501
R8 V V.n1 41.9633
R9 V.n1 V 12.1778
R10 V V.n0 2.4386
R11 V.n0 V 1.43601
R12 LO.n0 LO.t0 192.639
R13 LO.n1 LO.n0 152
R14 LO.n0 LO.t1 134.799
R15 LO.n1 LO 9.78757
R16 LO LO.n1 6.17193
R17 HI.n0 HI.t2 230.576
R18 HI.n1 HI.t1 206.19
R19 HI.n0 HI.t0 158.275
R20 HI.n4 HI.n0 152.268
R21 HI.n2 HI.n1 152
R22 HI.n1 HI.t3 148.35
R23 HI.n4 HI.n3 11.0554
R24 HI.n3 HI.n2 10.8751
R25 HI HI.n4 6.4005
R26 HI.n3 HI 1.19693
R27 HI.n2 HI 0.686214
R28 VDD.n6 VDD.t4 766.545
R29 VDD VDD.t0 547.509
R30 VDD.n1 VDD.n0 315.301
R31 VDD.t4 VDD 313.707
R32 VDD.t6 VDD 313.707
R33 VDD.t0 VDD.t2 287.072
R34 VDD.n3 VDD.t5 255.905
R35 VDD.t2 VDD.t6 213.084
R36 VDD.n0 VDD.t3 96.1553
R37 VDD.n12 VDD.n11 34.6358
R38 VDD.n13 VDD.n12 34.6358
R39 VDD.n8 VDD.n7 34.6358
R40 VDD.n0 VDD.t1 25.6105
R41 VDD.n7 VDD.n6 23.7181
R42 VDD.n8 VDD.n3 10.5417
R43 VDD.n13 VDD.n1 10.1652
R44 VDD.n6 VDD.n5 9.3005
R45 VDD.n7 VDD.n4 9.3005
R46 VDD.n9 VDD.n8 9.3005
R47 VDD.n11 VDD.n10 9.3005
R48 VDD.n12 VDD.n2 9.3005
R49 VDD.n14 VDD.n13 9.3005
R50 VDD.n11 VDD.n3 8.28285
R51 VDD.n15 VDD.n1 7.5914
R52 VDD VDD.n15 0.237498
R53 VDD.n15 VDD.n14 0.146355
R54 VDD.n9 VDD.n4 0.120292
R55 VDD.n10 VDD.n9 0.120292
R56 VDD.n14 VDD.n2 0.120292
R57 VDD VDD.n4 0.0890417
R58 VDD.n5 VDD 0.0603958
R59 VDD VDD.n2 0.0603958
R60 VDD.n5 VDD 0.03175
R61 VDD.n10 VDD 0.0226354
R62 GND.n7 GND.t4 3861.03
R63 GND GND.t0 2634.3
R64 GND.t4 GND 1509.39
R65 GND.t0 GND.t2 1381.23
R66 GND.t6 GND 1338.51
R67 GND.t2 GND.t6 1196.12
R68 GND.n19 GND.t7 246.506
R69 GND.n2 GND.n1 210.601
R70 GND.n4 GND.t5 158.361
R71 GND.n1 GND.t3 55.7148
R72 GND.n9 GND.n8 34.6358
R73 GND.n13 GND.n12 34.6358
R74 GND.n14 GND.n13 34.6358
R75 GND.n18 GND.n17 34.6358
R76 GND.n1 GND.t1 26.8576
R77 GND.n8 GND.n7 23.7181
R78 GND.n14 GND.n2 16.1887
R79 GND.n19 GND.n18 15.0593
R80 GND.n20 GND.n19 10.8064
R81 GND.n9 GND.n4 10.5417
R82 GND.n18 GND.n0 9.3005
R83 GND.n17 GND.n16 9.3005
R84 GND.n15 GND.n14 9.3005
R85 GND.n13 GND.n3 9.3005
R86 GND.n12 GND.n11 9.3005
R87 GND.n7 GND.n6 9.3005
R88 GND.n8 GND.n5 9.3005
R89 GND.n10 GND.n9 9.3005
R90 GND.n12 GND.n4 6.77697
R91 GND.n17 GND.n2 2.25932
R92 GND.n10 GND.n5 0.120292
R93 GND.n11 GND.n10 0.120292
R94 GND.n15 GND.n3 0.120292
R95 GND.n16 GND.n15 0.120292
R96 GND.n16 GND.n0 0.120292
R97 GND.n20 GND.n0 0.120292
R98 GND GND.n5 0.0877396
R99 GND.n6 GND 0.0603958
R100 GND GND.n3 0.0603958
R101 GND.n6 GND 0.0330521
R102 GND.n11 GND 0.0226354
R103 GND GND.n20 0.0226354
C0 LO HI 0.14021f
C1 VDD V 0.20359f
C2 VDD P 0.31039f
C3 V a_n288_n743# 0.10667f
C4 VDD a_n288_n743# 0.14624f
C5 V HI 0.14306f
C6 VDD HI 0.33248f
C7 a_n288_n743# HI 0.24818f
C8 LO a_n288_n743# 0.10369f
C9 P GND 0.37622f
C10 V GND 0.56984f
C11 LO GND 0.34842f
C12 HI GND 0.45638f
C13 VDD GND 1.5977f
C14 a_n288_n743# GND 0.22433f
C15 VDD.t0 GND 0.102f
C16 VDD.t4 GND 0.14473f
C17 VDD.n6 GND 0.13906f
C18 HI.n0 GND 0.12816f
C19 HI.n3 GND 0.31928f
C20 V.n0 GND 0.10773f
C21 V.n1 GND 0.14967f
.ends
